* Extracted by KLayout with SG13G2 LVS runset on : 25/09/2026 03:03

.SUBCKT ARRAY_3T_thin_L13n_P
M$1 \$3 \$9 \$4 \$1 sg13_lv_nmos L=0.13u W=0.15u AS=0.1005p AD=0.0555p PS=1.34u
+ PD=0.74u
M$2 \$4 \$10 \$5 \$1 sg13_lv_nmos L=0.13u W=0.15u AS=0.0555p AD=0.1005p
+ PS=0.74u PD=1.34u
M$3 \$2 \$8 \$12 \$6 sg13_lv_pmos L=0.13u W=0.3u AS=0.102p AD=0.0525p PS=1.28u
+ PD=0.65u
M$4 \$12 \$3 \$13 \$6 sg13_lv_pmos L=0.13u W=0.3u AS=0.0525p AD=0.33p PS=0.65u
+ PD=2.8u
M$5 \$14 \$5 \$15 \$7 sg13_lv_pmos L=0.13u W=0.3u AS=0.33p AD=0.0525p PS=2.8u
+ PD=0.65u
M$6 \$15 \$11 \$2 \$7 sg13_lv_pmos L=0.13u W=0.3u AS=0.0525p AD=0.102p PS=0.65u
+ PD=1.28u
.ENDS ARRAY_3T_thin_L13n_P
