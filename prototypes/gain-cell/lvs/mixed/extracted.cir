* Extracted by KLayout with SG13G2 LVS runset on : 25/09/2026 02:38

.SUBCKT ARRAY_MIXED
M$1 \$2 \$8 \$16 \$1 sg13_lv_nmos L=0.13u W=0.3u AS=0.102p AD=0.0525p PS=1.28u
+ PD=0.65u
M$2 \$16 \$3 \$17 \$1 sg13_lv_nmos L=0.13u W=0.3u AS=0.0525p AD=0.33p PS=0.65u
+ PD=2.8u
M$3 \$18 \$5 \$19 \$1 sg13_lv_nmos L=0.13u W=0.3u AS=0.33p AD=0.0525p PS=2.8u
+ PD=0.65u
M$4 \$19 \$11 \$2 \$1 sg13_lv_nmos L=0.13u W=0.3u AS=0.0525p AD=0.057p PS=0.65u
+ PD=0.68u
M$5 \$2 \$12 \$20 \$1 sg13_lv_nmos L=0.13u W=0.3u AS=0.057p AD=0.0525p PS=0.68u
+ PD=0.65u
M$6 \$20 \$6 \$21 \$1 sg13_lv_nmos L=0.13u W=0.3u AS=0.0525p AD=0.33p PS=0.65u
+ PD=2.8u
M$7 \$6 \$13 \$4 \$1 sg13_lv_nmos L=0.13u W=0.15u AS=0.1005p AD=0.0555p
+ PS=1.34u PD=0.74u
M$8 \$4 \$14 \$7 \$1 sg13_lv_nmos L=0.13u W=0.15u AS=0.0555p AD=0.1005p
+ PS=0.74u PD=1.34u
M$9 \$22 \$7 \$23 \$1 sg13_lv_nmos L=0.13u W=0.3u AS=0.33p AD=0.0525p PS=2.8u
+ PD=0.65u
M$10 \$23 \$15 \$2 \$1 sg13_lv_nmos L=0.13u W=0.3u AS=0.0525p AD=0.102p
+ PS=0.65u PD=1.28u
M$11 \$3 \$9 \$4 \$1 sg13_hv_nmos L=0.45u W=0.15u AS=0.1005p AD=0.0555p
+ PS=1.34u PD=0.74u
M$12 \$4 \$10 \$5 \$1 sg13_hv_nmos L=0.45u W=0.15u AS=0.0555p AD=0.1005p
+ PS=0.74u PD=1.34u
.ENDS ARRAY_MIXED
