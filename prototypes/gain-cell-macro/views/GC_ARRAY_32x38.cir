* GC_ARRAY_32x38: schematic for LVS (thick-oxide 3T gain cell, one per row and column)
.SUBCKT GC_ARRAY_32x38 RWL[0] RWL[1] RWL[2] RWL[3] RWL[4] RWL[5] RWL[6] RWL[7] RWL[8] RWL[9] RWL[10] RWL[11] RWL[12] RWL[13] RWL[14] RWL[15] RWL[16] RWL[17] RWL[18] RWL[19] RWL[20] RWL[21] RWL[22] RWL[23] RWL[24] RWL[25] RWL[26] RWL[27] RWL[28] RWL[29] RWL[30] RWL[31] WWL[0] WWL[1] WWL[2] WWL[3] WWL[4] WWL[5] WWL[6] WWL[7] WWL[8] WWL[9] WWL[10] WWL[11] WWL[12] WWL[13] WWL[14] WWL[15] WWL[16] WWL[17] WWL[18] WWL[19] WWL[20] WWL[21] WWL[22] WWL[23] WWL[24] WWL[25] WWL[26] WWL[27] WWL[28] WWL[29] WWL[30] WWL[31] RBL[0] RBL[1] RBL[2] RBL[3] RBL[4] RBL[5] RBL[6] RBL[7] RBL[8] RBL[9] RBL[10] RBL[11] RBL[12] RBL[13] RBL[14] RBL[15] RBL[16] RBL[17] RBL[18] RBL[19] RBL[20] RBL[21] RBL[22] RBL[23] RBL[24] RBL[25] RBL[26] RBL[27] RBL[28] RBL[29] RBL[30] RBL[31] RBL[32] RBL[33] RBL[34] RBL[35] RBL[36] RBL[37] WBL[0] WBL[1] WBL[2] WBL[3] WBL[4] WBL[5] WBL[6] WBL[7] WBL[8] WBL[9] WBL[10] WBL[11] WBL[12] WBL[13] WBL[14] WBL[15] WBL[16] WBL[17] WBL[18] WBL[19] WBL[20] WBL[21] WBL[22] WBL[23] WBL[24] WBL[25] WBL[26] WBL[27] WBL[28] WBL[29] WBL[30] WBL[31] WBL[32] WBL[33] WBL[34] WBL[35] WBL[36] WBL[37] GND
MMW_0_0 WBL[0] WWL[0] SN_0_0 GND sg13_hv_nmos W=0.15u L=0.45u
MMS_0_0 MID_0_0 SN_0_0 GND GND sg13_lv_nmos W=0.3u L=0.13u
MMR_0_0 RBL[0] RWL[0] MID_0_0 GND sg13_lv_nmos W=0.3u L=0.13u
MMW_0_1 WBL[1] WWL[0] SN_0_1 GND sg13_hv_nmos W=0.15u L=0.45u
MMS_0_1 MID_0_1 SN_0_1 GND GND sg13_lv_nmos W=0.3u L=0.13u
MMR_0_1 RBL[1] RWL[0] MID_0_1 GND sg13_lv_nmos W=0.3u L=0.13u
MMW_0_2 WBL[2] WWL[0] SN_0_2 GND sg13_hv_nmos W=0.15u L=0.45u
MMS_0_2 MID_0_2 SN_0_2 GND GND sg13_lv_nmos W=0.3u L=0.13u
MMR_0_2 RBL[2] RWL[0] MID_0_2 GND sg13_lv_nmos W=0.3u L=0.13u
MMW_0_3 WBL[3] WWL[0] SN_0_3 GND sg13_hv_nmos W=0.15u L=0.45u
MMS_0_3 MID_0_3 SN_0_3 GND GND sg13_lv_nmos W=0.3u L=0.13u
MMR_0_3 RBL[3] RWL[0] MID_0_3 GND sg13_lv_nmos W=0.3u L=0.13u
MMW_0_4 WBL[4] WWL[0] SN_0_4 GND sg13_hv_nmos W=0.15u L=0.45u
MMS_0_4 MID_0_4 SN_0_4 GND GND sg13_lv_nmos W=0.3u L=0.13u
MMR_0_4 RBL[4] RWL[0] MID_0_4 GND sg13_lv_nmos W=0.3u L=0.13u
MMW_0_5 WBL[5] WWL[0] SN_0_5 GND sg13_hv_nmos W=0.15u L=0.45u
MMS_0_5 MID_0_5 SN_0_5 GND GND sg13_lv_nmos W=0.3u L=0.13u
MMR_0_5 RBL[5] RWL[0] MID_0_5 GND sg13_lv_nmos W=0.3u L=0.13u
MMW_0_6 WBL[6] WWL[0] SN_0_6 GND sg13_hv_nmos W=0.15u L=0.45u
MMS_0_6 MID_0_6 SN_0_6 GND GND sg13_lv_nmos W=0.3u L=0.13u
MMR_0_6 RBL[6] RWL[0] MID_0_6 GND sg13_lv_nmos W=0.3u L=0.13u
MMW_0_7 WBL[7] WWL[0] SN_0_7 GND sg13_hv_nmos W=0.15u L=0.45u
MMS_0_7 MID_0_7 SN_0_7 GND GND sg13_lv_nmos W=0.3u L=0.13u
MMR_0_7 RBL[7] RWL[0] MID_0_7 GND sg13_lv_nmos W=0.3u L=0.13u
MMW_0_8 WBL[8] WWL[0] SN_0_8 GND sg13_hv_nmos W=0.15u L=0.45u
MMS_0_8 MID_0_8 SN_0_8 GND GND sg13_lv_nmos W=0.3u L=0.13u
MMR_0_8 RBL[8] RWL[0] MID_0_8 GND sg13_lv_nmos W=0.3u L=0.13u
MMW_0_9 WBL[9] WWL[0] SN_0_9 GND sg13_hv_nmos W=0.15u L=0.45u
MMS_0_9 MID_0_9 SN_0_9 GND GND sg13_lv_nmos W=0.3u L=0.13u
MMR_0_9 RBL[9] RWL[0] MID_0_9 GND sg13_lv_nmos W=0.3u L=0.13u
MMW_0_10 WBL[10] WWL[0] SN_0_10 GND sg13_hv_nmos W=0.15u L=0.45u
MMS_0_10 MID_0_10 SN_0_10 GND GND sg13_lv_nmos W=0.3u L=0.13u
MMR_0_10 RBL[10] RWL[0] MID_0_10 GND sg13_lv_nmos W=0.3u L=0.13u
MMW_0_11 WBL[11] WWL[0] SN_0_11 GND sg13_hv_nmos W=0.15u L=0.45u
MMS_0_11 MID_0_11 SN_0_11 GND GND sg13_lv_nmos W=0.3u L=0.13u
MMR_0_11 RBL[11] RWL[0] MID_0_11 GND sg13_lv_nmos W=0.3u L=0.13u
MMW_0_12 WBL[12] WWL[0] SN_0_12 GND sg13_hv_nmos W=0.15u L=0.45u
MMS_0_12 MID_0_12 SN_0_12 GND GND sg13_lv_nmos W=0.3u L=0.13u
MMR_0_12 RBL[12] RWL[0] MID_0_12 GND sg13_lv_nmos W=0.3u L=0.13u
MMW_0_13 WBL[13] WWL[0] SN_0_13 GND sg13_hv_nmos W=0.15u L=0.45u
MMS_0_13 MID_0_13 SN_0_13 GND GND sg13_lv_nmos W=0.3u L=0.13u
MMR_0_13 RBL[13] RWL[0] MID_0_13 GND sg13_lv_nmos W=0.3u L=0.13u
MMW_0_14 WBL[14] WWL[0] SN_0_14 GND sg13_hv_nmos W=0.15u L=0.45u
MMS_0_14 MID_0_14 SN_0_14 GND GND sg13_lv_nmos W=0.3u L=0.13u
MMR_0_14 RBL[14] RWL[0] MID_0_14 GND sg13_lv_nmos W=0.3u L=0.13u
MMW_0_15 WBL[15] WWL[0] SN_0_15 GND sg13_hv_nmos W=0.15u L=0.45u
MMS_0_15 MID_0_15 SN_0_15 GND GND sg13_lv_nmos W=0.3u L=0.13u
MMR_0_15 RBL[15] RWL[0] MID_0_15 GND sg13_lv_nmos W=0.3u L=0.13u
MMW_0_16 WBL[16] WWL[0] SN_0_16 GND sg13_hv_nmos W=0.15u L=0.45u
MMS_0_16 MID_0_16 SN_0_16 GND GND sg13_lv_nmos W=0.3u L=0.13u
MMR_0_16 RBL[16] RWL[0] MID_0_16 GND sg13_lv_nmos W=0.3u L=0.13u
MMW_0_17 WBL[17] WWL[0] SN_0_17 GND sg13_hv_nmos W=0.15u L=0.45u
MMS_0_17 MID_0_17 SN_0_17 GND GND sg13_lv_nmos W=0.3u L=0.13u
MMR_0_17 RBL[17] RWL[0] MID_0_17 GND sg13_lv_nmos W=0.3u L=0.13u
MMW_0_18 WBL[18] WWL[0] SN_0_18 GND sg13_hv_nmos W=0.15u L=0.45u
MMS_0_18 MID_0_18 SN_0_18 GND GND sg13_lv_nmos W=0.3u L=0.13u
MMR_0_18 RBL[18] RWL[0] MID_0_18 GND sg13_lv_nmos W=0.3u L=0.13u
MMW_0_19 WBL[19] WWL[0] SN_0_19 GND sg13_hv_nmos W=0.15u L=0.45u
MMS_0_19 MID_0_19 SN_0_19 GND GND sg13_lv_nmos W=0.3u L=0.13u
MMR_0_19 RBL[19] RWL[0] MID_0_19 GND sg13_lv_nmos W=0.3u L=0.13u
MMW_0_20 WBL[20] WWL[0] SN_0_20 GND sg13_hv_nmos W=0.15u L=0.45u
MMS_0_20 MID_0_20 SN_0_20 GND GND sg13_lv_nmos W=0.3u L=0.13u
MMR_0_20 RBL[20] RWL[0] MID_0_20 GND sg13_lv_nmos W=0.3u L=0.13u
MMW_0_21 WBL[21] WWL[0] SN_0_21 GND sg13_hv_nmos W=0.15u L=0.45u
MMS_0_21 MID_0_21 SN_0_21 GND GND sg13_lv_nmos W=0.3u L=0.13u
MMR_0_21 RBL[21] RWL[0] MID_0_21 GND sg13_lv_nmos W=0.3u L=0.13u
MMW_0_22 WBL[22] WWL[0] SN_0_22 GND sg13_hv_nmos W=0.15u L=0.45u
MMS_0_22 MID_0_22 SN_0_22 GND GND sg13_lv_nmos W=0.3u L=0.13u
MMR_0_22 RBL[22] RWL[0] MID_0_22 GND sg13_lv_nmos W=0.3u L=0.13u
MMW_0_23 WBL[23] WWL[0] SN_0_23 GND sg13_hv_nmos W=0.15u L=0.45u
MMS_0_23 MID_0_23 SN_0_23 GND GND sg13_lv_nmos W=0.3u L=0.13u
MMR_0_23 RBL[23] RWL[0] MID_0_23 GND sg13_lv_nmos W=0.3u L=0.13u
MMW_0_24 WBL[24] WWL[0] SN_0_24 GND sg13_hv_nmos W=0.15u L=0.45u
MMS_0_24 MID_0_24 SN_0_24 GND GND sg13_lv_nmos W=0.3u L=0.13u
MMR_0_24 RBL[24] RWL[0] MID_0_24 GND sg13_lv_nmos W=0.3u L=0.13u
MMW_0_25 WBL[25] WWL[0] SN_0_25 GND sg13_hv_nmos W=0.15u L=0.45u
MMS_0_25 MID_0_25 SN_0_25 GND GND sg13_lv_nmos W=0.3u L=0.13u
MMR_0_25 RBL[25] RWL[0] MID_0_25 GND sg13_lv_nmos W=0.3u L=0.13u
MMW_0_26 WBL[26] WWL[0] SN_0_26 GND sg13_hv_nmos W=0.15u L=0.45u
MMS_0_26 MID_0_26 SN_0_26 GND GND sg13_lv_nmos W=0.3u L=0.13u
MMR_0_26 RBL[26] RWL[0] MID_0_26 GND sg13_lv_nmos W=0.3u L=0.13u
MMW_0_27 WBL[27] WWL[0] SN_0_27 GND sg13_hv_nmos W=0.15u L=0.45u
MMS_0_27 MID_0_27 SN_0_27 GND GND sg13_lv_nmos W=0.3u L=0.13u
MMR_0_27 RBL[27] RWL[0] MID_0_27 GND sg13_lv_nmos W=0.3u L=0.13u
MMW_0_28 WBL[28] WWL[0] SN_0_28 GND sg13_hv_nmos W=0.15u L=0.45u
MMS_0_28 MID_0_28 SN_0_28 GND GND sg13_lv_nmos W=0.3u L=0.13u
MMR_0_28 RBL[28] RWL[0] MID_0_28 GND sg13_lv_nmos W=0.3u L=0.13u
MMW_0_29 WBL[29] WWL[0] SN_0_29 GND sg13_hv_nmos W=0.15u L=0.45u
MMS_0_29 MID_0_29 SN_0_29 GND GND sg13_lv_nmos W=0.3u L=0.13u
MMR_0_29 RBL[29] RWL[0] MID_0_29 GND sg13_lv_nmos W=0.3u L=0.13u
MMW_0_30 WBL[30] WWL[0] SN_0_30 GND sg13_hv_nmos W=0.15u L=0.45u
MMS_0_30 MID_0_30 SN_0_30 GND GND sg13_lv_nmos W=0.3u L=0.13u
MMR_0_30 RBL[30] RWL[0] MID_0_30 GND sg13_lv_nmos W=0.3u L=0.13u
MMW_0_31 WBL[31] WWL[0] SN_0_31 GND sg13_hv_nmos W=0.15u L=0.45u
MMS_0_31 MID_0_31 SN_0_31 GND GND sg13_lv_nmos W=0.3u L=0.13u
MMR_0_31 RBL[31] RWL[0] MID_0_31 GND sg13_lv_nmos W=0.3u L=0.13u
MMW_0_32 WBL[32] WWL[0] SN_0_32 GND sg13_hv_nmos W=0.15u L=0.45u
MMS_0_32 MID_0_32 SN_0_32 GND GND sg13_lv_nmos W=0.3u L=0.13u
MMR_0_32 RBL[32] RWL[0] MID_0_32 GND sg13_lv_nmos W=0.3u L=0.13u
MMW_0_33 WBL[33] WWL[0] SN_0_33 GND sg13_hv_nmos W=0.15u L=0.45u
MMS_0_33 MID_0_33 SN_0_33 GND GND sg13_lv_nmos W=0.3u L=0.13u
MMR_0_33 RBL[33] RWL[0] MID_0_33 GND sg13_lv_nmos W=0.3u L=0.13u
MMW_0_34 WBL[34] WWL[0] SN_0_34 GND sg13_hv_nmos W=0.15u L=0.45u
MMS_0_34 MID_0_34 SN_0_34 GND GND sg13_lv_nmos W=0.3u L=0.13u
MMR_0_34 RBL[34] RWL[0] MID_0_34 GND sg13_lv_nmos W=0.3u L=0.13u
MMW_0_35 WBL[35] WWL[0] SN_0_35 GND sg13_hv_nmos W=0.15u L=0.45u
MMS_0_35 MID_0_35 SN_0_35 GND GND sg13_lv_nmos W=0.3u L=0.13u
MMR_0_35 RBL[35] RWL[0] MID_0_35 GND sg13_lv_nmos W=0.3u L=0.13u
MMW_0_36 WBL[36] WWL[0] SN_0_36 GND sg13_hv_nmos W=0.15u L=0.45u
MMS_0_36 MID_0_36 SN_0_36 GND GND sg13_lv_nmos W=0.3u L=0.13u
MMR_0_36 RBL[36] RWL[0] MID_0_36 GND sg13_lv_nmos W=0.3u L=0.13u
MMW_0_37 WBL[37] WWL[0] SN_0_37 GND sg13_hv_nmos W=0.15u L=0.45u
MMS_0_37 MID_0_37 SN_0_37 GND GND sg13_lv_nmos W=0.3u L=0.13u
MMR_0_37 RBL[37] RWL[0] MID_0_37 GND sg13_lv_nmos W=0.3u L=0.13u
MMW_1_0 WBL[0] WWL[1] SN_1_0 GND sg13_hv_nmos W=0.15u L=0.45u
MMS_1_0 MID_1_0 SN_1_0 GND GND sg13_lv_nmos W=0.3u L=0.13u
MMR_1_0 RBL[0] RWL[1] MID_1_0 GND sg13_lv_nmos W=0.3u L=0.13u
MMW_1_1 WBL[1] WWL[1] SN_1_1 GND sg13_hv_nmos W=0.15u L=0.45u
MMS_1_1 MID_1_1 SN_1_1 GND GND sg13_lv_nmos W=0.3u L=0.13u
MMR_1_1 RBL[1] RWL[1] MID_1_1 GND sg13_lv_nmos W=0.3u L=0.13u
MMW_1_2 WBL[2] WWL[1] SN_1_2 GND sg13_hv_nmos W=0.15u L=0.45u
MMS_1_2 MID_1_2 SN_1_2 GND GND sg13_lv_nmos W=0.3u L=0.13u
MMR_1_2 RBL[2] RWL[1] MID_1_2 GND sg13_lv_nmos W=0.3u L=0.13u
MMW_1_3 WBL[3] WWL[1] SN_1_3 GND sg13_hv_nmos W=0.15u L=0.45u
MMS_1_3 MID_1_3 SN_1_3 GND GND sg13_lv_nmos W=0.3u L=0.13u
MMR_1_3 RBL[3] RWL[1] MID_1_3 GND sg13_lv_nmos W=0.3u L=0.13u
MMW_1_4 WBL[4] WWL[1] SN_1_4 GND sg13_hv_nmos W=0.15u L=0.45u
MMS_1_4 MID_1_4 SN_1_4 GND GND sg13_lv_nmos W=0.3u L=0.13u
MMR_1_4 RBL[4] RWL[1] MID_1_4 GND sg13_lv_nmos W=0.3u L=0.13u
MMW_1_5 WBL[5] WWL[1] SN_1_5 GND sg13_hv_nmos W=0.15u L=0.45u
MMS_1_5 MID_1_5 SN_1_5 GND GND sg13_lv_nmos W=0.3u L=0.13u
MMR_1_5 RBL[5] RWL[1] MID_1_5 GND sg13_lv_nmos W=0.3u L=0.13u
MMW_1_6 WBL[6] WWL[1] SN_1_6 GND sg13_hv_nmos W=0.15u L=0.45u
MMS_1_6 MID_1_6 SN_1_6 GND GND sg13_lv_nmos W=0.3u L=0.13u
MMR_1_6 RBL[6] RWL[1] MID_1_6 GND sg13_lv_nmos W=0.3u L=0.13u
MMW_1_7 WBL[7] WWL[1] SN_1_7 GND sg13_hv_nmos W=0.15u L=0.45u
MMS_1_7 MID_1_7 SN_1_7 GND GND sg13_lv_nmos W=0.3u L=0.13u
MMR_1_7 RBL[7] RWL[1] MID_1_7 GND sg13_lv_nmos W=0.3u L=0.13u
MMW_1_8 WBL[8] WWL[1] SN_1_8 GND sg13_hv_nmos W=0.15u L=0.45u
MMS_1_8 MID_1_8 SN_1_8 GND GND sg13_lv_nmos W=0.3u L=0.13u
MMR_1_8 RBL[8] RWL[1] MID_1_8 GND sg13_lv_nmos W=0.3u L=0.13u
MMW_1_9 WBL[9] WWL[1] SN_1_9 GND sg13_hv_nmos W=0.15u L=0.45u
MMS_1_9 MID_1_9 SN_1_9 GND GND sg13_lv_nmos W=0.3u L=0.13u
MMR_1_9 RBL[9] RWL[1] MID_1_9 GND sg13_lv_nmos W=0.3u L=0.13u
MMW_1_10 WBL[10] WWL[1] SN_1_10 GND sg13_hv_nmos W=0.15u L=0.45u
MMS_1_10 MID_1_10 SN_1_10 GND GND sg13_lv_nmos W=0.3u L=0.13u
MMR_1_10 RBL[10] RWL[1] MID_1_10 GND sg13_lv_nmos W=0.3u L=0.13u
MMW_1_11 WBL[11] WWL[1] SN_1_11 GND sg13_hv_nmos W=0.15u L=0.45u
MMS_1_11 MID_1_11 SN_1_11 GND GND sg13_lv_nmos W=0.3u L=0.13u
MMR_1_11 RBL[11] RWL[1] MID_1_11 GND sg13_lv_nmos W=0.3u L=0.13u
MMW_1_12 WBL[12] WWL[1] SN_1_12 GND sg13_hv_nmos W=0.15u L=0.45u
MMS_1_12 MID_1_12 SN_1_12 GND GND sg13_lv_nmos W=0.3u L=0.13u
MMR_1_12 RBL[12] RWL[1] MID_1_12 GND sg13_lv_nmos W=0.3u L=0.13u
MMW_1_13 WBL[13] WWL[1] SN_1_13 GND sg13_hv_nmos W=0.15u L=0.45u
MMS_1_13 MID_1_13 SN_1_13 GND GND sg13_lv_nmos W=0.3u L=0.13u
MMR_1_13 RBL[13] RWL[1] MID_1_13 GND sg13_lv_nmos W=0.3u L=0.13u
MMW_1_14 WBL[14] WWL[1] SN_1_14 GND sg13_hv_nmos W=0.15u L=0.45u
MMS_1_14 MID_1_14 SN_1_14 GND GND sg13_lv_nmos W=0.3u L=0.13u
MMR_1_14 RBL[14] RWL[1] MID_1_14 GND sg13_lv_nmos W=0.3u L=0.13u
MMW_1_15 WBL[15] WWL[1] SN_1_15 GND sg13_hv_nmos W=0.15u L=0.45u
MMS_1_15 MID_1_15 SN_1_15 GND GND sg13_lv_nmos W=0.3u L=0.13u
MMR_1_15 RBL[15] RWL[1] MID_1_15 GND sg13_lv_nmos W=0.3u L=0.13u
MMW_1_16 WBL[16] WWL[1] SN_1_16 GND sg13_hv_nmos W=0.15u L=0.45u
MMS_1_16 MID_1_16 SN_1_16 GND GND sg13_lv_nmos W=0.3u L=0.13u
MMR_1_16 RBL[16] RWL[1] MID_1_16 GND sg13_lv_nmos W=0.3u L=0.13u
MMW_1_17 WBL[17] WWL[1] SN_1_17 GND sg13_hv_nmos W=0.15u L=0.45u
MMS_1_17 MID_1_17 SN_1_17 GND GND sg13_lv_nmos W=0.3u L=0.13u
MMR_1_17 RBL[17] RWL[1] MID_1_17 GND sg13_lv_nmos W=0.3u L=0.13u
MMW_1_18 WBL[18] WWL[1] SN_1_18 GND sg13_hv_nmos W=0.15u L=0.45u
MMS_1_18 MID_1_18 SN_1_18 GND GND sg13_lv_nmos W=0.3u L=0.13u
MMR_1_18 RBL[18] RWL[1] MID_1_18 GND sg13_lv_nmos W=0.3u L=0.13u
MMW_1_19 WBL[19] WWL[1] SN_1_19 GND sg13_hv_nmos W=0.15u L=0.45u
MMS_1_19 MID_1_19 SN_1_19 GND GND sg13_lv_nmos W=0.3u L=0.13u
MMR_1_19 RBL[19] RWL[1] MID_1_19 GND sg13_lv_nmos W=0.3u L=0.13u
MMW_1_20 WBL[20] WWL[1] SN_1_20 GND sg13_hv_nmos W=0.15u L=0.45u
MMS_1_20 MID_1_20 SN_1_20 GND GND sg13_lv_nmos W=0.3u L=0.13u
MMR_1_20 RBL[20] RWL[1] MID_1_20 GND sg13_lv_nmos W=0.3u L=0.13u
MMW_1_21 WBL[21] WWL[1] SN_1_21 GND sg13_hv_nmos W=0.15u L=0.45u
MMS_1_21 MID_1_21 SN_1_21 GND GND sg13_lv_nmos W=0.3u L=0.13u
MMR_1_21 RBL[21] RWL[1] MID_1_21 GND sg13_lv_nmos W=0.3u L=0.13u
MMW_1_22 WBL[22] WWL[1] SN_1_22 GND sg13_hv_nmos W=0.15u L=0.45u
MMS_1_22 MID_1_22 SN_1_22 GND GND sg13_lv_nmos W=0.3u L=0.13u
MMR_1_22 RBL[22] RWL[1] MID_1_22 GND sg13_lv_nmos W=0.3u L=0.13u
MMW_1_23 WBL[23] WWL[1] SN_1_23 GND sg13_hv_nmos W=0.15u L=0.45u
MMS_1_23 MID_1_23 SN_1_23 GND GND sg13_lv_nmos W=0.3u L=0.13u
MMR_1_23 RBL[23] RWL[1] MID_1_23 GND sg13_lv_nmos W=0.3u L=0.13u
MMW_1_24 WBL[24] WWL[1] SN_1_24 GND sg13_hv_nmos W=0.15u L=0.45u
MMS_1_24 MID_1_24 SN_1_24 GND GND sg13_lv_nmos W=0.3u L=0.13u
MMR_1_24 RBL[24] RWL[1] MID_1_24 GND sg13_lv_nmos W=0.3u L=0.13u
MMW_1_25 WBL[25] WWL[1] SN_1_25 GND sg13_hv_nmos W=0.15u L=0.45u
MMS_1_25 MID_1_25 SN_1_25 GND GND sg13_lv_nmos W=0.3u L=0.13u
MMR_1_25 RBL[25] RWL[1] MID_1_25 GND sg13_lv_nmos W=0.3u L=0.13u
MMW_1_26 WBL[26] WWL[1] SN_1_26 GND sg13_hv_nmos W=0.15u L=0.45u
MMS_1_26 MID_1_26 SN_1_26 GND GND sg13_lv_nmos W=0.3u L=0.13u
MMR_1_26 RBL[26] RWL[1] MID_1_26 GND sg13_lv_nmos W=0.3u L=0.13u
MMW_1_27 WBL[27] WWL[1] SN_1_27 GND sg13_hv_nmos W=0.15u L=0.45u
MMS_1_27 MID_1_27 SN_1_27 GND GND sg13_lv_nmos W=0.3u L=0.13u
MMR_1_27 RBL[27] RWL[1] MID_1_27 GND sg13_lv_nmos W=0.3u L=0.13u
MMW_1_28 WBL[28] WWL[1] SN_1_28 GND sg13_hv_nmos W=0.15u L=0.45u
MMS_1_28 MID_1_28 SN_1_28 GND GND sg13_lv_nmos W=0.3u L=0.13u
MMR_1_28 RBL[28] RWL[1] MID_1_28 GND sg13_lv_nmos W=0.3u L=0.13u
MMW_1_29 WBL[29] WWL[1] SN_1_29 GND sg13_hv_nmos W=0.15u L=0.45u
MMS_1_29 MID_1_29 SN_1_29 GND GND sg13_lv_nmos W=0.3u L=0.13u
MMR_1_29 RBL[29] RWL[1] MID_1_29 GND sg13_lv_nmos W=0.3u L=0.13u
MMW_1_30 WBL[30] WWL[1] SN_1_30 GND sg13_hv_nmos W=0.15u L=0.45u
MMS_1_30 MID_1_30 SN_1_30 GND GND sg13_lv_nmos W=0.3u L=0.13u
MMR_1_30 RBL[30] RWL[1] MID_1_30 GND sg13_lv_nmos W=0.3u L=0.13u
MMW_1_31 WBL[31] WWL[1] SN_1_31 GND sg13_hv_nmos W=0.15u L=0.45u
MMS_1_31 MID_1_31 SN_1_31 GND GND sg13_lv_nmos W=0.3u L=0.13u
MMR_1_31 RBL[31] RWL[1] MID_1_31 GND sg13_lv_nmos W=0.3u L=0.13u
MMW_1_32 WBL[32] WWL[1] SN_1_32 GND sg13_hv_nmos W=0.15u L=0.45u
MMS_1_32 MID_1_32 SN_1_32 GND GND sg13_lv_nmos W=0.3u L=0.13u
MMR_1_32 RBL[32] RWL[1] MID_1_32 GND sg13_lv_nmos W=0.3u L=0.13u
MMW_1_33 WBL[33] WWL[1] SN_1_33 GND sg13_hv_nmos W=0.15u L=0.45u
MMS_1_33 MID_1_33 SN_1_33 GND GND sg13_lv_nmos W=0.3u L=0.13u
MMR_1_33 RBL[33] RWL[1] MID_1_33 GND sg13_lv_nmos W=0.3u L=0.13u
MMW_1_34 WBL[34] WWL[1] SN_1_34 GND sg13_hv_nmos W=0.15u L=0.45u
MMS_1_34 MID_1_34 SN_1_34 GND GND sg13_lv_nmos W=0.3u L=0.13u
MMR_1_34 RBL[34] RWL[1] MID_1_34 GND sg13_lv_nmos W=0.3u L=0.13u
MMW_1_35 WBL[35] WWL[1] SN_1_35 GND sg13_hv_nmos W=0.15u L=0.45u
MMS_1_35 MID_1_35 SN_1_35 GND GND sg13_lv_nmos W=0.3u L=0.13u
MMR_1_35 RBL[35] RWL[1] MID_1_35 GND sg13_lv_nmos W=0.3u L=0.13u
MMW_1_36 WBL[36] WWL[1] SN_1_36 GND sg13_hv_nmos W=0.15u L=0.45u
MMS_1_36 MID_1_36 SN_1_36 GND GND sg13_lv_nmos W=0.3u L=0.13u
MMR_1_36 RBL[36] RWL[1] MID_1_36 GND sg13_lv_nmos W=0.3u L=0.13u
MMW_1_37 WBL[37] WWL[1] SN_1_37 GND sg13_hv_nmos W=0.15u L=0.45u
MMS_1_37 MID_1_37 SN_1_37 GND GND sg13_lv_nmos W=0.3u L=0.13u
MMR_1_37 RBL[37] RWL[1] MID_1_37 GND sg13_lv_nmos W=0.3u L=0.13u
MMW_2_0 WBL[0] WWL[2] SN_2_0 GND sg13_hv_nmos W=0.15u L=0.45u
MMS_2_0 MID_2_0 SN_2_0 GND GND sg13_lv_nmos W=0.3u L=0.13u
MMR_2_0 RBL[0] RWL[2] MID_2_0 GND sg13_lv_nmos W=0.3u L=0.13u
MMW_2_1 WBL[1] WWL[2] SN_2_1 GND sg13_hv_nmos W=0.15u L=0.45u
MMS_2_1 MID_2_1 SN_2_1 GND GND sg13_lv_nmos W=0.3u L=0.13u
MMR_2_1 RBL[1] RWL[2] MID_2_1 GND sg13_lv_nmos W=0.3u L=0.13u
MMW_2_2 WBL[2] WWL[2] SN_2_2 GND sg13_hv_nmos W=0.15u L=0.45u
MMS_2_2 MID_2_2 SN_2_2 GND GND sg13_lv_nmos W=0.3u L=0.13u
MMR_2_2 RBL[2] RWL[2] MID_2_2 GND sg13_lv_nmos W=0.3u L=0.13u
MMW_2_3 WBL[3] WWL[2] SN_2_3 GND sg13_hv_nmos W=0.15u L=0.45u
MMS_2_3 MID_2_3 SN_2_3 GND GND sg13_lv_nmos W=0.3u L=0.13u
MMR_2_3 RBL[3] RWL[2] MID_2_3 GND sg13_lv_nmos W=0.3u L=0.13u
MMW_2_4 WBL[4] WWL[2] SN_2_4 GND sg13_hv_nmos W=0.15u L=0.45u
MMS_2_4 MID_2_4 SN_2_4 GND GND sg13_lv_nmos W=0.3u L=0.13u
MMR_2_4 RBL[4] RWL[2] MID_2_4 GND sg13_lv_nmos W=0.3u L=0.13u
MMW_2_5 WBL[5] WWL[2] SN_2_5 GND sg13_hv_nmos W=0.15u L=0.45u
MMS_2_5 MID_2_5 SN_2_5 GND GND sg13_lv_nmos W=0.3u L=0.13u
MMR_2_5 RBL[5] RWL[2] MID_2_5 GND sg13_lv_nmos W=0.3u L=0.13u
MMW_2_6 WBL[6] WWL[2] SN_2_6 GND sg13_hv_nmos W=0.15u L=0.45u
MMS_2_6 MID_2_6 SN_2_6 GND GND sg13_lv_nmos W=0.3u L=0.13u
MMR_2_6 RBL[6] RWL[2] MID_2_6 GND sg13_lv_nmos W=0.3u L=0.13u
MMW_2_7 WBL[7] WWL[2] SN_2_7 GND sg13_hv_nmos W=0.15u L=0.45u
MMS_2_7 MID_2_7 SN_2_7 GND GND sg13_lv_nmos W=0.3u L=0.13u
MMR_2_7 RBL[7] RWL[2] MID_2_7 GND sg13_lv_nmos W=0.3u L=0.13u
MMW_2_8 WBL[8] WWL[2] SN_2_8 GND sg13_hv_nmos W=0.15u L=0.45u
MMS_2_8 MID_2_8 SN_2_8 GND GND sg13_lv_nmos W=0.3u L=0.13u
MMR_2_8 RBL[8] RWL[2] MID_2_8 GND sg13_lv_nmos W=0.3u L=0.13u
MMW_2_9 WBL[9] WWL[2] SN_2_9 GND sg13_hv_nmos W=0.15u L=0.45u
MMS_2_9 MID_2_9 SN_2_9 GND GND sg13_lv_nmos W=0.3u L=0.13u
MMR_2_9 RBL[9] RWL[2] MID_2_9 GND sg13_lv_nmos W=0.3u L=0.13u
MMW_2_10 WBL[10] WWL[2] SN_2_10 GND sg13_hv_nmos W=0.15u L=0.45u
MMS_2_10 MID_2_10 SN_2_10 GND GND sg13_lv_nmos W=0.3u L=0.13u
MMR_2_10 RBL[10] RWL[2] MID_2_10 GND sg13_lv_nmos W=0.3u L=0.13u
MMW_2_11 WBL[11] WWL[2] SN_2_11 GND sg13_hv_nmos W=0.15u L=0.45u
MMS_2_11 MID_2_11 SN_2_11 GND GND sg13_lv_nmos W=0.3u L=0.13u
MMR_2_11 RBL[11] RWL[2] MID_2_11 GND sg13_lv_nmos W=0.3u L=0.13u
MMW_2_12 WBL[12] WWL[2] SN_2_12 GND sg13_hv_nmos W=0.15u L=0.45u
MMS_2_12 MID_2_12 SN_2_12 GND GND sg13_lv_nmos W=0.3u L=0.13u
MMR_2_12 RBL[12] RWL[2] MID_2_12 GND sg13_lv_nmos W=0.3u L=0.13u
MMW_2_13 WBL[13] WWL[2] SN_2_13 GND sg13_hv_nmos W=0.15u L=0.45u
MMS_2_13 MID_2_13 SN_2_13 GND GND sg13_lv_nmos W=0.3u L=0.13u
MMR_2_13 RBL[13] RWL[2] MID_2_13 GND sg13_lv_nmos W=0.3u L=0.13u
MMW_2_14 WBL[14] WWL[2] SN_2_14 GND sg13_hv_nmos W=0.15u L=0.45u
MMS_2_14 MID_2_14 SN_2_14 GND GND sg13_lv_nmos W=0.3u L=0.13u
MMR_2_14 RBL[14] RWL[2] MID_2_14 GND sg13_lv_nmos W=0.3u L=0.13u
MMW_2_15 WBL[15] WWL[2] SN_2_15 GND sg13_hv_nmos W=0.15u L=0.45u
MMS_2_15 MID_2_15 SN_2_15 GND GND sg13_lv_nmos W=0.3u L=0.13u
MMR_2_15 RBL[15] RWL[2] MID_2_15 GND sg13_lv_nmos W=0.3u L=0.13u
MMW_2_16 WBL[16] WWL[2] SN_2_16 GND sg13_hv_nmos W=0.15u L=0.45u
MMS_2_16 MID_2_16 SN_2_16 GND GND sg13_lv_nmos W=0.3u L=0.13u
MMR_2_16 RBL[16] RWL[2] MID_2_16 GND sg13_lv_nmos W=0.3u L=0.13u
MMW_2_17 WBL[17] WWL[2] SN_2_17 GND sg13_hv_nmos W=0.15u L=0.45u
MMS_2_17 MID_2_17 SN_2_17 GND GND sg13_lv_nmos W=0.3u L=0.13u
MMR_2_17 RBL[17] RWL[2] MID_2_17 GND sg13_lv_nmos W=0.3u L=0.13u
MMW_2_18 WBL[18] WWL[2] SN_2_18 GND sg13_hv_nmos W=0.15u L=0.45u
MMS_2_18 MID_2_18 SN_2_18 GND GND sg13_lv_nmos W=0.3u L=0.13u
MMR_2_18 RBL[18] RWL[2] MID_2_18 GND sg13_lv_nmos W=0.3u L=0.13u
MMW_2_19 WBL[19] WWL[2] SN_2_19 GND sg13_hv_nmos W=0.15u L=0.45u
MMS_2_19 MID_2_19 SN_2_19 GND GND sg13_lv_nmos W=0.3u L=0.13u
MMR_2_19 RBL[19] RWL[2] MID_2_19 GND sg13_lv_nmos W=0.3u L=0.13u
MMW_2_20 WBL[20] WWL[2] SN_2_20 GND sg13_hv_nmos W=0.15u L=0.45u
MMS_2_20 MID_2_20 SN_2_20 GND GND sg13_lv_nmos W=0.3u L=0.13u
MMR_2_20 RBL[20] RWL[2] MID_2_20 GND sg13_lv_nmos W=0.3u L=0.13u
MMW_2_21 WBL[21] WWL[2] SN_2_21 GND sg13_hv_nmos W=0.15u L=0.45u
MMS_2_21 MID_2_21 SN_2_21 GND GND sg13_lv_nmos W=0.3u L=0.13u
MMR_2_21 RBL[21] RWL[2] MID_2_21 GND sg13_lv_nmos W=0.3u L=0.13u
MMW_2_22 WBL[22] WWL[2] SN_2_22 GND sg13_hv_nmos W=0.15u L=0.45u
MMS_2_22 MID_2_22 SN_2_22 GND GND sg13_lv_nmos W=0.3u L=0.13u
MMR_2_22 RBL[22] RWL[2] MID_2_22 GND sg13_lv_nmos W=0.3u L=0.13u
MMW_2_23 WBL[23] WWL[2] SN_2_23 GND sg13_hv_nmos W=0.15u L=0.45u
MMS_2_23 MID_2_23 SN_2_23 GND GND sg13_lv_nmos W=0.3u L=0.13u
MMR_2_23 RBL[23] RWL[2] MID_2_23 GND sg13_lv_nmos W=0.3u L=0.13u
MMW_2_24 WBL[24] WWL[2] SN_2_24 GND sg13_hv_nmos W=0.15u L=0.45u
MMS_2_24 MID_2_24 SN_2_24 GND GND sg13_lv_nmos W=0.3u L=0.13u
MMR_2_24 RBL[24] RWL[2] MID_2_24 GND sg13_lv_nmos W=0.3u L=0.13u
MMW_2_25 WBL[25] WWL[2] SN_2_25 GND sg13_hv_nmos W=0.15u L=0.45u
MMS_2_25 MID_2_25 SN_2_25 GND GND sg13_lv_nmos W=0.3u L=0.13u
MMR_2_25 RBL[25] RWL[2] MID_2_25 GND sg13_lv_nmos W=0.3u L=0.13u
MMW_2_26 WBL[26] WWL[2] SN_2_26 GND sg13_hv_nmos W=0.15u L=0.45u
MMS_2_26 MID_2_26 SN_2_26 GND GND sg13_lv_nmos W=0.3u L=0.13u
MMR_2_26 RBL[26] RWL[2] MID_2_26 GND sg13_lv_nmos W=0.3u L=0.13u
MMW_2_27 WBL[27] WWL[2] SN_2_27 GND sg13_hv_nmos W=0.15u L=0.45u
MMS_2_27 MID_2_27 SN_2_27 GND GND sg13_lv_nmos W=0.3u L=0.13u
MMR_2_27 RBL[27] RWL[2] MID_2_27 GND sg13_lv_nmos W=0.3u L=0.13u
MMW_2_28 WBL[28] WWL[2] SN_2_28 GND sg13_hv_nmos W=0.15u L=0.45u
MMS_2_28 MID_2_28 SN_2_28 GND GND sg13_lv_nmos W=0.3u L=0.13u
MMR_2_28 RBL[28] RWL[2] MID_2_28 GND sg13_lv_nmos W=0.3u L=0.13u
MMW_2_29 WBL[29] WWL[2] SN_2_29 GND sg13_hv_nmos W=0.15u L=0.45u
MMS_2_29 MID_2_29 SN_2_29 GND GND sg13_lv_nmos W=0.3u L=0.13u
MMR_2_29 RBL[29] RWL[2] MID_2_29 GND sg13_lv_nmos W=0.3u L=0.13u
MMW_2_30 WBL[30] WWL[2] SN_2_30 GND sg13_hv_nmos W=0.15u L=0.45u
MMS_2_30 MID_2_30 SN_2_30 GND GND sg13_lv_nmos W=0.3u L=0.13u
MMR_2_30 RBL[30] RWL[2] MID_2_30 GND sg13_lv_nmos W=0.3u L=0.13u
MMW_2_31 WBL[31] WWL[2] SN_2_31 GND sg13_hv_nmos W=0.15u L=0.45u
MMS_2_31 MID_2_31 SN_2_31 GND GND sg13_lv_nmos W=0.3u L=0.13u
MMR_2_31 RBL[31] RWL[2] MID_2_31 GND sg13_lv_nmos W=0.3u L=0.13u
MMW_2_32 WBL[32] WWL[2] SN_2_32 GND sg13_hv_nmos W=0.15u L=0.45u
MMS_2_32 MID_2_32 SN_2_32 GND GND sg13_lv_nmos W=0.3u L=0.13u
MMR_2_32 RBL[32] RWL[2] MID_2_32 GND sg13_lv_nmos W=0.3u L=0.13u
MMW_2_33 WBL[33] WWL[2] SN_2_33 GND sg13_hv_nmos W=0.15u L=0.45u
MMS_2_33 MID_2_33 SN_2_33 GND GND sg13_lv_nmos W=0.3u L=0.13u
MMR_2_33 RBL[33] RWL[2] MID_2_33 GND sg13_lv_nmos W=0.3u L=0.13u
MMW_2_34 WBL[34] WWL[2] SN_2_34 GND sg13_hv_nmos W=0.15u L=0.45u
MMS_2_34 MID_2_34 SN_2_34 GND GND sg13_lv_nmos W=0.3u L=0.13u
MMR_2_34 RBL[34] RWL[2] MID_2_34 GND sg13_lv_nmos W=0.3u L=0.13u
MMW_2_35 WBL[35] WWL[2] SN_2_35 GND sg13_hv_nmos W=0.15u L=0.45u
MMS_2_35 MID_2_35 SN_2_35 GND GND sg13_lv_nmos W=0.3u L=0.13u
MMR_2_35 RBL[35] RWL[2] MID_2_35 GND sg13_lv_nmos W=0.3u L=0.13u
MMW_2_36 WBL[36] WWL[2] SN_2_36 GND sg13_hv_nmos W=0.15u L=0.45u
MMS_2_36 MID_2_36 SN_2_36 GND GND sg13_lv_nmos W=0.3u L=0.13u
MMR_2_36 RBL[36] RWL[2] MID_2_36 GND sg13_lv_nmos W=0.3u L=0.13u
MMW_2_37 WBL[37] WWL[2] SN_2_37 GND sg13_hv_nmos W=0.15u L=0.45u
MMS_2_37 MID_2_37 SN_2_37 GND GND sg13_lv_nmos W=0.3u L=0.13u
MMR_2_37 RBL[37] RWL[2] MID_2_37 GND sg13_lv_nmos W=0.3u L=0.13u
MMW_3_0 WBL[0] WWL[3] SN_3_0 GND sg13_hv_nmos W=0.15u L=0.45u
MMS_3_0 MID_3_0 SN_3_0 GND GND sg13_lv_nmos W=0.3u L=0.13u
MMR_3_0 RBL[0] RWL[3] MID_3_0 GND sg13_lv_nmos W=0.3u L=0.13u
MMW_3_1 WBL[1] WWL[3] SN_3_1 GND sg13_hv_nmos W=0.15u L=0.45u
MMS_3_1 MID_3_1 SN_3_1 GND GND sg13_lv_nmos W=0.3u L=0.13u
MMR_3_1 RBL[1] RWL[3] MID_3_1 GND sg13_lv_nmos W=0.3u L=0.13u
MMW_3_2 WBL[2] WWL[3] SN_3_2 GND sg13_hv_nmos W=0.15u L=0.45u
MMS_3_2 MID_3_2 SN_3_2 GND GND sg13_lv_nmos W=0.3u L=0.13u
MMR_3_2 RBL[2] RWL[3] MID_3_2 GND sg13_lv_nmos W=0.3u L=0.13u
MMW_3_3 WBL[3] WWL[3] SN_3_3 GND sg13_hv_nmos W=0.15u L=0.45u
MMS_3_3 MID_3_3 SN_3_3 GND GND sg13_lv_nmos W=0.3u L=0.13u
MMR_3_3 RBL[3] RWL[3] MID_3_3 GND sg13_lv_nmos W=0.3u L=0.13u
MMW_3_4 WBL[4] WWL[3] SN_3_4 GND sg13_hv_nmos W=0.15u L=0.45u
MMS_3_4 MID_3_4 SN_3_4 GND GND sg13_lv_nmos W=0.3u L=0.13u
MMR_3_4 RBL[4] RWL[3] MID_3_4 GND sg13_lv_nmos W=0.3u L=0.13u
MMW_3_5 WBL[5] WWL[3] SN_3_5 GND sg13_hv_nmos W=0.15u L=0.45u
MMS_3_5 MID_3_5 SN_3_5 GND GND sg13_lv_nmos W=0.3u L=0.13u
MMR_3_5 RBL[5] RWL[3] MID_3_5 GND sg13_lv_nmos W=0.3u L=0.13u
MMW_3_6 WBL[6] WWL[3] SN_3_6 GND sg13_hv_nmos W=0.15u L=0.45u
MMS_3_6 MID_3_6 SN_3_6 GND GND sg13_lv_nmos W=0.3u L=0.13u
MMR_3_6 RBL[6] RWL[3] MID_3_6 GND sg13_lv_nmos W=0.3u L=0.13u
MMW_3_7 WBL[7] WWL[3] SN_3_7 GND sg13_hv_nmos W=0.15u L=0.45u
MMS_3_7 MID_3_7 SN_3_7 GND GND sg13_lv_nmos W=0.3u L=0.13u
MMR_3_7 RBL[7] RWL[3] MID_3_7 GND sg13_lv_nmos W=0.3u L=0.13u
MMW_3_8 WBL[8] WWL[3] SN_3_8 GND sg13_hv_nmos W=0.15u L=0.45u
MMS_3_8 MID_3_8 SN_3_8 GND GND sg13_lv_nmos W=0.3u L=0.13u
MMR_3_8 RBL[8] RWL[3] MID_3_8 GND sg13_lv_nmos W=0.3u L=0.13u
MMW_3_9 WBL[9] WWL[3] SN_3_9 GND sg13_hv_nmos W=0.15u L=0.45u
MMS_3_9 MID_3_9 SN_3_9 GND GND sg13_lv_nmos W=0.3u L=0.13u
MMR_3_9 RBL[9] RWL[3] MID_3_9 GND sg13_lv_nmos W=0.3u L=0.13u
MMW_3_10 WBL[10] WWL[3] SN_3_10 GND sg13_hv_nmos W=0.15u L=0.45u
MMS_3_10 MID_3_10 SN_3_10 GND GND sg13_lv_nmos W=0.3u L=0.13u
MMR_3_10 RBL[10] RWL[3] MID_3_10 GND sg13_lv_nmos W=0.3u L=0.13u
MMW_3_11 WBL[11] WWL[3] SN_3_11 GND sg13_hv_nmos W=0.15u L=0.45u
MMS_3_11 MID_3_11 SN_3_11 GND GND sg13_lv_nmos W=0.3u L=0.13u
MMR_3_11 RBL[11] RWL[3] MID_3_11 GND sg13_lv_nmos W=0.3u L=0.13u
MMW_3_12 WBL[12] WWL[3] SN_3_12 GND sg13_hv_nmos W=0.15u L=0.45u
MMS_3_12 MID_3_12 SN_3_12 GND GND sg13_lv_nmos W=0.3u L=0.13u
MMR_3_12 RBL[12] RWL[3] MID_3_12 GND sg13_lv_nmos W=0.3u L=0.13u
MMW_3_13 WBL[13] WWL[3] SN_3_13 GND sg13_hv_nmos W=0.15u L=0.45u
MMS_3_13 MID_3_13 SN_3_13 GND GND sg13_lv_nmos W=0.3u L=0.13u
MMR_3_13 RBL[13] RWL[3] MID_3_13 GND sg13_lv_nmos W=0.3u L=0.13u
MMW_3_14 WBL[14] WWL[3] SN_3_14 GND sg13_hv_nmos W=0.15u L=0.45u
MMS_3_14 MID_3_14 SN_3_14 GND GND sg13_lv_nmos W=0.3u L=0.13u
MMR_3_14 RBL[14] RWL[3] MID_3_14 GND sg13_lv_nmos W=0.3u L=0.13u
MMW_3_15 WBL[15] WWL[3] SN_3_15 GND sg13_hv_nmos W=0.15u L=0.45u
MMS_3_15 MID_3_15 SN_3_15 GND GND sg13_lv_nmos W=0.3u L=0.13u
MMR_3_15 RBL[15] RWL[3] MID_3_15 GND sg13_lv_nmos W=0.3u L=0.13u
MMW_3_16 WBL[16] WWL[3] SN_3_16 GND sg13_hv_nmos W=0.15u L=0.45u
MMS_3_16 MID_3_16 SN_3_16 GND GND sg13_lv_nmos W=0.3u L=0.13u
MMR_3_16 RBL[16] RWL[3] MID_3_16 GND sg13_lv_nmos W=0.3u L=0.13u
MMW_3_17 WBL[17] WWL[3] SN_3_17 GND sg13_hv_nmos W=0.15u L=0.45u
MMS_3_17 MID_3_17 SN_3_17 GND GND sg13_lv_nmos W=0.3u L=0.13u
MMR_3_17 RBL[17] RWL[3] MID_3_17 GND sg13_lv_nmos W=0.3u L=0.13u
MMW_3_18 WBL[18] WWL[3] SN_3_18 GND sg13_hv_nmos W=0.15u L=0.45u
MMS_3_18 MID_3_18 SN_3_18 GND GND sg13_lv_nmos W=0.3u L=0.13u
MMR_3_18 RBL[18] RWL[3] MID_3_18 GND sg13_lv_nmos W=0.3u L=0.13u
MMW_3_19 WBL[19] WWL[3] SN_3_19 GND sg13_hv_nmos W=0.15u L=0.45u
MMS_3_19 MID_3_19 SN_3_19 GND GND sg13_lv_nmos W=0.3u L=0.13u
MMR_3_19 RBL[19] RWL[3] MID_3_19 GND sg13_lv_nmos W=0.3u L=0.13u
MMW_3_20 WBL[20] WWL[3] SN_3_20 GND sg13_hv_nmos W=0.15u L=0.45u
MMS_3_20 MID_3_20 SN_3_20 GND GND sg13_lv_nmos W=0.3u L=0.13u
MMR_3_20 RBL[20] RWL[3] MID_3_20 GND sg13_lv_nmos W=0.3u L=0.13u
MMW_3_21 WBL[21] WWL[3] SN_3_21 GND sg13_hv_nmos W=0.15u L=0.45u
MMS_3_21 MID_3_21 SN_3_21 GND GND sg13_lv_nmos W=0.3u L=0.13u
MMR_3_21 RBL[21] RWL[3] MID_3_21 GND sg13_lv_nmos W=0.3u L=0.13u
MMW_3_22 WBL[22] WWL[3] SN_3_22 GND sg13_hv_nmos W=0.15u L=0.45u
MMS_3_22 MID_3_22 SN_3_22 GND GND sg13_lv_nmos W=0.3u L=0.13u
MMR_3_22 RBL[22] RWL[3] MID_3_22 GND sg13_lv_nmos W=0.3u L=0.13u
MMW_3_23 WBL[23] WWL[3] SN_3_23 GND sg13_hv_nmos W=0.15u L=0.45u
MMS_3_23 MID_3_23 SN_3_23 GND GND sg13_lv_nmos W=0.3u L=0.13u
MMR_3_23 RBL[23] RWL[3] MID_3_23 GND sg13_lv_nmos W=0.3u L=0.13u
MMW_3_24 WBL[24] WWL[3] SN_3_24 GND sg13_hv_nmos W=0.15u L=0.45u
MMS_3_24 MID_3_24 SN_3_24 GND GND sg13_lv_nmos W=0.3u L=0.13u
MMR_3_24 RBL[24] RWL[3] MID_3_24 GND sg13_lv_nmos W=0.3u L=0.13u
MMW_3_25 WBL[25] WWL[3] SN_3_25 GND sg13_hv_nmos W=0.15u L=0.45u
MMS_3_25 MID_3_25 SN_3_25 GND GND sg13_lv_nmos W=0.3u L=0.13u
MMR_3_25 RBL[25] RWL[3] MID_3_25 GND sg13_lv_nmos W=0.3u L=0.13u
MMW_3_26 WBL[26] WWL[3] SN_3_26 GND sg13_hv_nmos W=0.15u L=0.45u
MMS_3_26 MID_3_26 SN_3_26 GND GND sg13_lv_nmos W=0.3u L=0.13u
MMR_3_26 RBL[26] RWL[3] MID_3_26 GND sg13_lv_nmos W=0.3u L=0.13u
MMW_3_27 WBL[27] WWL[3] SN_3_27 GND sg13_hv_nmos W=0.15u L=0.45u
MMS_3_27 MID_3_27 SN_3_27 GND GND sg13_lv_nmos W=0.3u L=0.13u
MMR_3_27 RBL[27] RWL[3] MID_3_27 GND sg13_lv_nmos W=0.3u L=0.13u
MMW_3_28 WBL[28] WWL[3] SN_3_28 GND sg13_hv_nmos W=0.15u L=0.45u
MMS_3_28 MID_3_28 SN_3_28 GND GND sg13_lv_nmos W=0.3u L=0.13u
MMR_3_28 RBL[28] RWL[3] MID_3_28 GND sg13_lv_nmos W=0.3u L=0.13u
MMW_3_29 WBL[29] WWL[3] SN_3_29 GND sg13_hv_nmos W=0.15u L=0.45u
MMS_3_29 MID_3_29 SN_3_29 GND GND sg13_lv_nmos W=0.3u L=0.13u
MMR_3_29 RBL[29] RWL[3] MID_3_29 GND sg13_lv_nmos W=0.3u L=0.13u
MMW_3_30 WBL[30] WWL[3] SN_3_30 GND sg13_hv_nmos W=0.15u L=0.45u
MMS_3_30 MID_3_30 SN_3_30 GND GND sg13_lv_nmos W=0.3u L=0.13u
MMR_3_30 RBL[30] RWL[3] MID_3_30 GND sg13_lv_nmos W=0.3u L=0.13u
MMW_3_31 WBL[31] WWL[3] SN_3_31 GND sg13_hv_nmos W=0.15u L=0.45u
MMS_3_31 MID_3_31 SN_3_31 GND GND sg13_lv_nmos W=0.3u L=0.13u
MMR_3_31 RBL[31] RWL[3] MID_3_31 GND sg13_lv_nmos W=0.3u L=0.13u
MMW_3_32 WBL[32] WWL[3] SN_3_32 GND sg13_hv_nmos W=0.15u L=0.45u
MMS_3_32 MID_3_32 SN_3_32 GND GND sg13_lv_nmos W=0.3u L=0.13u
MMR_3_32 RBL[32] RWL[3] MID_3_32 GND sg13_lv_nmos W=0.3u L=0.13u
MMW_3_33 WBL[33] WWL[3] SN_3_33 GND sg13_hv_nmos W=0.15u L=0.45u
MMS_3_33 MID_3_33 SN_3_33 GND GND sg13_lv_nmos W=0.3u L=0.13u
MMR_3_33 RBL[33] RWL[3] MID_3_33 GND sg13_lv_nmos W=0.3u L=0.13u
MMW_3_34 WBL[34] WWL[3] SN_3_34 GND sg13_hv_nmos W=0.15u L=0.45u
MMS_3_34 MID_3_34 SN_3_34 GND GND sg13_lv_nmos W=0.3u L=0.13u
MMR_3_34 RBL[34] RWL[3] MID_3_34 GND sg13_lv_nmos W=0.3u L=0.13u
MMW_3_35 WBL[35] WWL[3] SN_3_35 GND sg13_hv_nmos W=0.15u L=0.45u
MMS_3_35 MID_3_35 SN_3_35 GND GND sg13_lv_nmos W=0.3u L=0.13u
MMR_3_35 RBL[35] RWL[3] MID_3_35 GND sg13_lv_nmos W=0.3u L=0.13u
MMW_3_36 WBL[36] WWL[3] SN_3_36 GND sg13_hv_nmos W=0.15u L=0.45u
MMS_3_36 MID_3_36 SN_3_36 GND GND sg13_lv_nmos W=0.3u L=0.13u
MMR_3_36 RBL[36] RWL[3] MID_3_36 GND sg13_lv_nmos W=0.3u L=0.13u
MMW_3_37 WBL[37] WWL[3] SN_3_37 GND sg13_hv_nmos W=0.15u L=0.45u
MMS_3_37 MID_3_37 SN_3_37 GND GND sg13_lv_nmos W=0.3u L=0.13u
MMR_3_37 RBL[37] RWL[3] MID_3_37 GND sg13_lv_nmos W=0.3u L=0.13u
MMW_4_0 WBL[0] WWL[4] SN_4_0 GND sg13_hv_nmos W=0.15u L=0.45u
MMS_4_0 MID_4_0 SN_4_0 GND GND sg13_lv_nmos W=0.3u L=0.13u
MMR_4_0 RBL[0] RWL[4] MID_4_0 GND sg13_lv_nmos W=0.3u L=0.13u
MMW_4_1 WBL[1] WWL[4] SN_4_1 GND sg13_hv_nmos W=0.15u L=0.45u
MMS_4_1 MID_4_1 SN_4_1 GND GND sg13_lv_nmos W=0.3u L=0.13u
MMR_4_1 RBL[1] RWL[4] MID_4_1 GND sg13_lv_nmos W=0.3u L=0.13u
MMW_4_2 WBL[2] WWL[4] SN_4_2 GND sg13_hv_nmos W=0.15u L=0.45u
MMS_4_2 MID_4_2 SN_4_2 GND GND sg13_lv_nmos W=0.3u L=0.13u
MMR_4_2 RBL[2] RWL[4] MID_4_2 GND sg13_lv_nmos W=0.3u L=0.13u
MMW_4_3 WBL[3] WWL[4] SN_4_3 GND sg13_hv_nmos W=0.15u L=0.45u
MMS_4_3 MID_4_3 SN_4_3 GND GND sg13_lv_nmos W=0.3u L=0.13u
MMR_4_3 RBL[3] RWL[4] MID_4_3 GND sg13_lv_nmos W=0.3u L=0.13u
MMW_4_4 WBL[4] WWL[4] SN_4_4 GND sg13_hv_nmos W=0.15u L=0.45u
MMS_4_4 MID_4_4 SN_4_4 GND GND sg13_lv_nmos W=0.3u L=0.13u
MMR_4_4 RBL[4] RWL[4] MID_4_4 GND sg13_lv_nmos W=0.3u L=0.13u
MMW_4_5 WBL[5] WWL[4] SN_4_5 GND sg13_hv_nmos W=0.15u L=0.45u
MMS_4_5 MID_4_5 SN_4_5 GND GND sg13_lv_nmos W=0.3u L=0.13u
MMR_4_5 RBL[5] RWL[4] MID_4_5 GND sg13_lv_nmos W=0.3u L=0.13u
MMW_4_6 WBL[6] WWL[4] SN_4_6 GND sg13_hv_nmos W=0.15u L=0.45u
MMS_4_6 MID_4_6 SN_4_6 GND GND sg13_lv_nmos W=0.3u L=0.13u
MMR_4_6 RBL[6] RWL[4] MID_4_6 GND sg13_lv_nmos W=0.3u L=0.13u
MMW_4_7 WBL[7] WWL[4] SN_4_7 GND sg13_hv_nmos W=0.15u L=0.45u
MMS_4_7 MID_4_7 SN_4_7 GND GND sg13_lv_nmos W=0.3u L=0.13u
MMR_4_7 RBL[7] RWL[4] MID_4_7 GND sg13_lv_nmos W=0.3u L=0.13u
MMW_4_8 WBL[8] WWL[4] SN_4_8 GND sg13_hv_nmos W=0.15u L=0.45u
MMS_4_8 MID_4_8 SN_4_8 GND GND sg13_lv_nmos W=0.3u L=0.13u
MMR_4_8 RBL[8] RWL[4] MID_4_8 GND sg13_lv_nmos W=0.3u L=0.13u
MMW_4_9 WBL[9] WWL[4] SN_4_9 GND sg13_hv_nmos W=0.15u L=0.45u
MMS_4_9 MID_4_9 SN_4_9 GND GND sg13_lv_nmos W=0.3u L=0.13u
MMR_4_9 RBL[9] RWL[4] MID_4_9 GND sg13_lv_nmos W=0.3u L=0.13u
MMW_4_10 WBL[10] WWL[4] SN_4_10 GND sg13_hv_nmos W=0.15u L=0.45u
MMS_4_10 MID_4_10 SN_4_10 GND GND sg13_lv_nmos W=0.3u L=0.13u
MMR_4_10 RBL[10] RWL[4] MID_4_10 GND sg13_lv_nmos W=0.3u L=0.13u
MMW_4_11 WBL[11] WWL[4] SN_4_11 GND sg13_hv_nmos W=0.15u L=0.45u
MMS_4_11 MID_4_11 SN_4_11 GND GND sg13_lv_nmos W=0.3u L=0.13u
MMR_4_11 RBL[11] RWL[4] MID_4_11 GND sg13_lv_nmos W=0.3u L=0.13u
MMW_4_12 WBL[12] WWL[4] SN_4_12 GND sg13_hv_nmos W=0.15u L=0.45u
MMS_4_12 MID_4_12 SN_4_12 GND GND sg13_lv_nmos W=0.3u L=0.13u
MMR_4_12 RBL[12] RWL[4] MID_4_12 GND sg13_lv_nmos W=0.3u L=0.13u
MMW_4_13 WBL[13] WWL[4] SN_4_13 GND sg13_hv_nmos W=0.15u L=0.45u
MMS_4_13 MID_4_13 SN_4_13 GND GND sg13_lv_nmos W=0.3u L=0.13u
MMR_4_13 RBL[13] RWL[4] MID_4_13 GND sg13_lv_nmos W=0.3u L=0.13u
MMW_4_14 WBL[14] WWL[4] SN_4_14 GND sg13_hv_nmos W=0.15u L=0.45u
MMS_4_14 MID_4_14 SN_4_14 GND GND sg13_lv_nmos W=0.3u L=0.13u
MMR_4_14 RBL[14] RWL[4] MID_4_14 GND sg13_lv_nmos W=0.3u L=0.13u
MMW_4_15 WBL[15] WWL[4] SN_4_15 GND sg13_hv_nmos W=0.15u L=0.45u
MMS_4_15 MID_4_15 SN_4_15 GND GND sg13_lv_nmos W=0.3u L=0.13u
MMR_4_15 RBL[15] RWL[4] MID_4_15 GND sg13_lv_nmos W=0.3u L=0.13u
MMW_4_16 WBL[16] WWL[4] SN_4_16 GND sg13_hv_nmos W=0.15u L=0.45u
MMS_4_16 MID_4_16 SN_4_16 GND GND sg13_lv_nmos W=0.3u L=0.13u
MMR_4_16 RBL[16] RWL[4] MID_4_16 GND sg13_lv_nmos W=0.3u L=0.13u
MMW_4_17 WBL[17] WWL[4] SN_4_17 GND sg13_hv_nmos W=0.15u L=0.45u
MMS_4_17 MID_4_17 SN_4_17 GND GND sg13_lv_nmos W=0.3u L=0.13u
MMR_4_17 RBL[17] RWL[4] MID_4_17 GND sg13_lv_nmos W=0.3u L=0.13u
MMW_4_18 WBL[18] WWL[4] SN_4_18 GND sg13_hv_nmos W=0.15u L=0.45u
MMS_4_18 MID_4_18 SN_4_18 GND GND sg13_lv_nmos W=0.3u L=0.13u
MMR_4_18 RBL[18] RWL[4] MID_4_18 GND sg13_lv_nmos W=0.3u L=0.13u
MMW_4_19 WBL[19] WWL[4] SN_4_19 GND sg13_hv_nmos W=0.15u L=0.45u
MMS_4_19 MID_4_19 SN_4_19 GND GND sg13_lv_nmos W=0.3u L=0.13u
MMR_4_19 RBL[19] RWL[4] MID_4_19 GND sg13_lv_nmos W=0.3u L=0.13u
MMW_4_20 WBL[20] WWL[4] SN_4_20 GND sg13_hv_nmos W=0.15u L=0.45u
MMS_4_20 MID_4_20 SN_4_20 GND GND sg13_lv_nmos W=0.3u L=0.13u
MMR_4_20 RBL[20] RWL[4] MID_4_20 GND sg13_lv_nmos W=0.3u L=0.13u
MMW_4_21 WBL[21] WWL[4] SN_4_21 GND sg13_hv_nmos W=0.15u L=0.45u
MMS_4_21 MID_4_21 SN_4_21 GND GND sg13_lv_nmos W=0.3u L=0.13u
MMR_4_21 RBL[21] RWL[4] MID_4_21 GND sg13_lv_nmos W=0.3u L=0.13u
MMW_4_22 WBL[22] WWL[4] SN_4_22 GND sg13_hv_nmos W=0.15u L=0.45u
MMS_4_22 MID_4_22 SN_4_22 GND GND sg13_lv_nmos W=0.3u L=0.13u
MMR_4_22 RBL[22] RWL[4] MID_4_22 GND sg13_lv_nmos W=0.3u L=0.13u
MMW_4_23 WBL[23] WWL[4] SN_4_23 GND sg13_hv_nmos W=0.15u L=0.45u
MMS_4_23 MID_4_23 SN_4_23 GND GND sg13_lv_nmos W=0.3u L=0.13u
MMR_4_23 RBL[23] RWL[4] MID_4_23 GND sg13_lv_nmos W=0.3u L=0.13u
MMW_4_24 WBL[24] WWL[4] SN_4_24 GND sg13_hv_nmos W=0.15u L=0.45u
MMS_4_24 MID_4_24 SN_4_24 GND GND sg13_lv_nmos W=0.3u L=0.13u
MMR_4_24 RBL[24] RWL[4] MID_4_24 GND sg13_lv_nmos W=0.3u L=0.13u
MMW_4_25 WBL[25] WWL[4] SN_4_25 GND sg13_hv_nmos W=0.15u L=0.45u
MMS_4_25 MID_4_25 SN_4_25 GND GND sg13_lv_nmos W=0.3u L=0.13u
MMR_4_25 RBL[25] RWL[4] MID_4_25 GND sg13_lv_nmos W=0.3u L=0.13u
MMW_4_26 WBL[26] WWL[4] SN_4_26 GND sg13_hv_nmos W=0.15u L=0.45u
MMS_4_26 MID_4_26 SN_4_26 GND GND sg13_lv_nmos W=0.3u L=0.13u
MMR_4_26 RBL[26] RWL[4] MID_4_26 GND sg13_lv_nmos W=0.3u L=0.13u
MMW_4_27 WBL[27] WWL[4] SN_4_27 GND sg13_hv_nmos W=0.15u L=0.45u
MMS_4_27 MID_4_27 SN_4_27 GND GND sg13_lv_nmos W=0.3u L=0.13u
MMR_4_27 RBL[27] RWL[4] MID_4_27 GND sg13_lv_nmos W=0.3u L=0.13u
MMW_4_28 WBL[28] WWL[4] SN_4_28 GND sg13_hv_nmos W=0.15u L=0.45u
MMS_4_28 MID_4_28 SN_4_28 GND GND sg13_lv_nmos W=0.3u L=0.13u
MMR_4_28 RBL[28] RWL[4] MID_4_28 GND sg13_lv_nmos W=0.3u L=0.13u
MMW_4_29 WBL[29] WWL[4] SN_4_29 GND sg13_hv_nmos W=0.15u L=0.45u
MMS_4_29 MID_4_29 SN_4_29 GND GND sg13_lv_nmos W=0.3u L=0.13u
MMR_4_29 RBL[29] RWL[4] MID_4_29 GND sg13_lv_nmos W=0.3u L=0.13u
MMW_4_30 WBL[30] WWL[4] SN_4_30 GND sg13_hv_nmos W=0.15u L=0.45u
MMS_4_30 MID_4_30 SN_4_30 GND GND sg13_lv_nmos W=0.3u L=0.13u
MMR_4_30 RBL[30] RWL[4] MID_4_30 GND sg13_lv_nmos W=0.3u L=0.13u
MMW_4_31 WBL[31] WWL[4] SN_4_31 GND sg13_hv_nmos W=0.15u L=0.45u
MMS_4_31 MID_4_31 SN_4_31 GND GND sg13_lv_nmos W=0.3u L=0.13u
MMR_4_31 RBL[31] RWL[4] MID_4_31 GND sg13_lv_nmos W=0.3u L=0.13u
MMW_4_32 WBL[32] WWL[4] SN_4_32 GND sg13_hv_nmos W=0.15u L=0.45u
MMS_4_32 MID_4_32 SN_4_32 GND GND sg13_lv_nmos W=0.3u L=0.13u
MMR_4_32 RBL[32] RWL[4] MID_4_32 GND sg13_lv_nmos W=0.3u L=0.13u
MMW_4_33 WBL[33] WWL[4] SN_4_33 GND sg13_hv_nmos W=0.15u L=0.45u
MMS_4_33 MID_4_33 SN_4_33 GND GND sg13_lv_nmos W=0.3u L=0.13u
MMR_4_33 RBL[33] RWL[4] MID_4_33 GND sg13_lv_nmos W=0.3u L=0.13u
MMW_4_34 WBL[34] WWL[4] SN_4_34 GND sg13_hv_nmos W=0.15u L=0.45u
MMS_4_34 MID_4_34 SN_4_34 GND GND sg13_lv_nmos W=0.3u L=0.13u
MMR_4_34 RBL[34] RWL[4] MID_4_34 GND sg13_lv_nmos W=0.3u L=0.13u
MMW_4_35 WBL[35] WWL[4] SN_4_35 GND sg13_hv_nmos W=0.15u L=0.45u
MMS_4_35 MID_4_35 SN_4_35 GND GND sg13_lv_nmos W=0.3u L=0.13u
MMR_4_35 RBL[35] RWL[4] MID_4_35 GND sg13_lv_nmos W=0.3u L=0.13u
MMW_4_36 WBL[36] WWL[4] SN_4_36 GND sg13_hv_nmos W=0.15u L=0.45u
MMS_4_36 MID_4_36 SN_4_36 GND GND sg13_lv_nmos W=0.3u L=0.13u
MMR_4_36 RBL[36] RWL[4] MID_4_36 GND sg13_lv_nmos W=0.3u L=0.13u
MMW_4_37 WBL[37] WWL[4] SN_4_37 GND sg13_hv_nmos W=0.15u L=0.45u
MMS_4_37 MID_4_37 SN_4_37 GND GND sg13_lv_nmos W=0.3u L=0.13u
MMR_4_37 RBL[37] RWL[4] MID_4_37 GND sg13_lv_nmos W=0.3u L=0.13u
MMW_5_0 WBL[0] WWL[5] SN_5_0 GND sg13_hv_nmos W=0.15u L=0.45u
MMS_5_0 MID_5_0 SN_5_0 GND GND sg13_lv_nmos W=0.3u L=0.13u
MMR_5_0 RBL[0] RWL[5] MID_5_0 GND sg13_lv_nmos W=0.3u L=0.13u
MMW_5_1 WBL[1] WWL[5] SN_5_1 GND sg13_hv_nmos W=0.15u L=0.45u
MMS_5_1 MID_5_1 SN_5_1 GND GND sg13_lv_nmos W=0.3u L=0.13u
MMR_5_1 RBL[1] RWL[5] MID_5_1 GND sg13_lv_nmos W=0.3u L=0.13u
MMW_5_2 WBL[2] WWL[5] SN_5_2 GND sg13_hv_nmos W=0.15u L=0.45u
MMS_5_2 MID_5_2 SN_5_2 GND GND sg13_lv_nmos W=0.3u L=0.13u
MMR_5_2 RBL[2] RWL[5] MID_5_2 GND sg13_lv_nmos W=0.3u L=0.13u
MMW_5_3 WBL[3] WWL[5] SN_5_3 GND sg13_hv_nmos W=0.15u L=0.45u
MMS_5_3 MID_5_3 SN_5_3 GND GND sg13_lv_nmos W=0.3u L=0.13u
MMR_5_3 RBL[3] RWL[5] MID_5_3 GND sg13_lv_nmos W=0.3u L=0.13u
MMW_5_4 WBL[4] WWL[5] SN_5_4 GND sg13_hv_nmos W=0.15u L=0.45u
MMS_5_4 MID_5_4 SN_5_4 GND GND sg13_lv_nmos W=0.3u L=0.13u
MMR_5_4 RBL[4] RWL[5] MID_5_4 GND sg13_lv_nmos W=0.3u L=0.13u
MMW_5_5 WBL[5] WWL[5] SN_5_5 GND sg13_hv_nmos W=0.15u L=0.45u
MMS_5_5 MID_5_5 SN_5_5 GND GND sg13_lv_nmos W=0.3u L=0.13u
MMR_5_5 RBL[5] RWL[5] MID_5_5 GND sg13_lv_nmos W=0.3u L=0.13u
MMW_5_6 WBL[6] WWL[5] SN_5_6 GND sg13_hv_nmos W=0.15u L=0.45u
MMS_5_6 MID_5_6 SN_5_6 GND GND sg13_lv_nmos W=0.3u L=0.13u
MMR_5_6 RBL[6] RWL[5] MID_5_6 GND sg13_lv_nmos W=0.3u L=0.13u
MMW_5_7 WBL[7] WWL[5] SN_5_7 GND sg13_hv_nmos W=0.15u L=0.45u
MMS_5_7 MID_5_7 SN_5_7 GND GND sg13_lv_nmos W=0.3u L=0.13u
MMR_5_7 RBL[7] RWL[5] MID_5_7 GND sg13_lv_nmos W=0.3u L=0.13u
MMW_5_8 WBL[8] WWL[5] SN_5_8 GND sg13_hv_nmos W=0.15u L=0.45u
MMS_5_8 MID_5_8 SN_5_8 GND GND sg13_lv_nmos W=0.3u L=0.13u
MMR_5_8 RBL[8] RWL[5] MID_5_8 GND sg13_lv_nmos W=0.3u L=0.13u
MMW_5_9 WBL[9] WWL[5] SN_5_9 GND sg13_hv_nmos W=0.15u L=0.45u
MMS_5_9 MID_5_9 SN_5_9 GND GND sg13_lv_nmos W=0.3u L=0.13u
MMR_5_9 RBL[9] RWL[5] MID_5_9 GND sg13_lv_nmos W=0.3u L=0.13u
MMW_5_10 WBL[10] WWL[5] SN_5_10 GND sg13_hv_nmos W=0.15u L=0.45u
MMS_5_10 MID_5_10 SN_5_10 GND GND sg13_lv_nmos W=0.3u L=0.13u
MMR_5_10 RBL[10] RWL[5] MID_5_10 GND sg13_lv_nmos W=0.3u L=0.13u
MMW_5_11 WBL[11] WWL[5] SN_5_11 GND sg13_hv_nmos W=0.15u L=0.45u
MMS_5_11 MID_5_11 SN_5_11 GND GND sg13_lv_nmos W=0.3u L=0.13u
MMR_5_11 RBL[11] RWL[5] MID_5_11 GND sg13_lv_nmos W=0.3u L=0.13u
MMW_5_12 WBL[12] WWL[5] SN_5_12 GND sg13_hv_nmos W=0.15u L=0.45u
MMS_5_12 MID_5_12 SN_5_12 GND GND sg13_lv_nmos W=0.3u L=0.13u
MMR_5_12 RBL[12] RWL[5] MID_5_12 GND sg13_lv_nmos W=0.3u L=0.13u
MMW_5_13 WBL[13] WWL[5] SN_5_13 GND sg13_hv_nmos W=0.15u L=0.45u
MMS_5_13 MID_5_13 SN_5_13 GND GND sg13_lv_nmos W=0.3u L=0.13u
MMR_5_13 RBL[13] RWL[5] MID_5_13 GND sg13_lv_nmos W=0.3u L=0.13u
MMW_5_14 WBL[14] WWL[5] SN_5_14 GND sg13_hv_nmos W=0.15u L=0.45u
MMS_5_14 MID_5_14 SN_5_14 GND GND sg13_lv_nmos W=0.3u L=0.13u
MMR_5_14 RBL[14] RWL[5] MID_5_14 GND sg13_lv_nmos W=0.3u L=0.13u
MMW_5_15 WBL[15] WWL[5] SN_5_15 GND sg13_hv_nmos W=0.15u L=0.45u
MMS_5_15 MID_5_15 SN_5_15 GND GND sg13_lv_nmos W=0.3u L=0.13u
MMR_5_15 RBL[15] RWL[5] MID_5_15 GND sg13_lv_nmos W=0.3u L=0.13u
MMW_5_16 WBL[16] WWL[5] SN_5_16 GND sg13_hv_nmos W=0.15u L=0.45u
MMS_5_16 MID_5_16 SN_5_16 GND GND sg13_lv_nmos W=0.3u L=0.13u
MMR_5_16 RBL[16] RWL[5] MID_5_16 GND sg13_lv_nmos W=0.3u L=0.13u
MMW_5_17 WBL[17] WWL[5] SN_5_17 GND sg13_hv_nmos W=0.15u L=0.45u
MMS_5_17 MID_5_17 SN_5_17 GND GND sg13_lv_nmos W=0.3u L=0.13u
MMR_5_17 RBL[17] RWL[5] MID_5_17 GND sg13_lv_nmos W=0.3u L=0.13u
MMW_5_18 WBL[18] WWL[5] SN_5_18 GND sg13_hv_nmos W=0.15u L=0.45u
MMS_5_18 MID_5_18 SN_5_18 GND GND sg13_lv_nmos W=0.3u L=0.13u
MMR_5_18 RBL[18] RWL[5] MID_5_18 GND sg13_lv_nmos W=0.3u L=0.13u
MMW_5_19 WBL[19] WWL[5] SN_5_19 GND sg13_hv_nmos W=0.15u L=0.45u
MMS_5_19 MID_5_19 SN_5_19 GND GND sg13_lv_nmos W=0.3u L=0.13u
MMR_5_19 RBL[19] RWL[5] MID_5_19 GND sg13_lv_nmos W=0.3u L=0.13u
MMW_5_20 WBL[20] WWL[5] SN_5_20 GND sg13_hv_nmos W=0.15u L=0.45u
MMS_5_20 MID_5_20 SN_5_20 GND GND sg13_lv_nmos W=0.3u L=0.13u
MMR_5_20 RBL[20] RWL[5] MID_5_20 GND sg13_lv_nmos W=0.3u L=0.13u
MMW_5_21 WBL[21] WWL[5] SN_5_21 GND sg13_hv_nmos W=0.15u L=0.45u
MMS_5_21 MID_5_21 SN_5_21 GND GND sg13_lv_nmos W=0.3u L=0.13u
MMR_5_21 RBL[21] RWL[5] MID_5_21 GND sg13_lv_nmos W=0.3u L=0.13u
MMW_5_22 WBL[22] WWL[5] SN_5_22 GND sg13_hv_nmos W=0.15u L=0.45u
MMS_5_22 MID_5_22 SN_5_22 GND GND sg13_lv_nmos W=0.3u L=0.13u
MMR_5_22 RBL[22] RWL[5] MID_5_22 GND sg13_lv_nmos W=0.3u L=0.13u
MMW_5_23 WBL[23] WWL[5] SN_5_23 GND sg13_hv_nmos W=0.15u L=0.45u
MMS_5_23 MID_5_23 SN_5_23 GND GND sg13_lv_nmos W=0.3u L=0.13u
MMR_5_23 RBL[23] RWL[5] MID_5_23 GND sg13_lv_nmos W=0.3u L=0.13u
MMW_5_24 WBL[24] WWL[5] SN_5_24 GND sg13_hv_nmos W=0.15u L=0.45u
MMS_5_24 MID_5_24 SN_5_24 GND GND sg13_lv_nmos W=0.3u L=0.13u
MMR_5_24 RBL[24] RWL[5] MID_5_24 GND sg13_lv_nmos W=0.3u L=0.13u
MMW_5_25 WBL[25] WWL[5] SN_5_25 GND sg13_hv_nmos W=0.15u L=0.45u
MMS_5_25 MID_5_25 SN_5_25 GND GND sg13_lv_nmos W=0.3u L=0.13u
MMR_5_25 RBL[25] RWL[5] MID_5_25 GND sg13_lv_nmos W=0.3u L=0.13u
MMW_5_26 WBL[26] WWL[5] SN_5_26 GND sg13_hv_nmos W=0.15u L=0.45u
MMS_5_26 MID_5_26 SN_5_26 GND GND sg13_lv_nmos W=0.3u L=0.13u
MMR_5_26 RBL[26] RWL[5] MID_5_26 GND sg13_lv_nmos W=0.3u L=0.13u
MMW_5_27 WBL[27] WWL[5] SN_5_27 GND sg13_hv_nmos W=0.15u L=0.45u
MMS_5_27 MID_5_27 SN_5_27 GND GND sg13_lv_nmos W=0.3u L=0.13u
MMR_5_27 RBL[27] RWL[5] MID_5_27 GND sg13_lv_nmos W=0.3u L=0.13u
MMW_5_28 WBL[28] WWL[5] SN_5_28 GND sg13_hv_nmos W=0.15u L=0.45u
MMS_5_28 MID_5_28 SN_5_28 GND GND sg13_lv_nmos W=0.3u L=0.13u
MMR_5_28 RBL[28] RWL[5] MID_5_28 GND sg13_lv_nmos W=0.3u L=0.13u
MMW_5_29 WBL[29] WWL[5] SN_5_29 GND sg13_hv_nmos W=0.15u L=0.45u
MMS_5_29 MID_5_29 SN_5_29 GND GND sg13_lv_nmos W=0.3u L=0.13u
MMR_5_29 RBL[29] RWL[5] MID_5_29 GND sg13_lv_nmos W=0.3u L=0.13u
MMW_5_30 WBL[30] WWL[5] SN_5_30 GND sg13_hv_nmos W=0.15u L=0.45u
MMS_5_30 MID_5_30 SN_5_30 GND GND sg13_lv_nmos W=0.3u L=0.13u
MMR_5_30 RBL[30] RWL[5] MID_5_30 GND sg13_lv_nmos W=0.3u L=0.13u
MMW_5_31 WBL[31] WWL[5] SN_5_31 GND sg13_hv_nmos W=0.15u L=0.45u
MMS_5_31 MID_5_31 SN_5_31 GND GND sg13_lv_nmos W=0.3u L=0.13u
MMR_5_31 RBL[31] RWL[5] MID_5_31 GND sg13_lv_nmos W=0.3u L=0.13u
MMW_5_32 WBL[32] WWL[5] SN_5_32 GND sg13_hv_nmos W=0.15u L=0.45u
MMS_5_32 MID_5_32 SN_5_32 GND GND sg13_lv_nmos W=0.3u L=0.13u
MMR_5_32 RBL[32] RWL[5] MID_5_32 GND sg13_lv_nmos W=0.3u L=0.13u
MMW_5_33 WBL[33] WWL[5] SN_5_33 GND sg13_hv_nmos W=0.15u L=0.45u
MMS_5_33 MID_5_33 SN_5_33 GND GND sg13_lv_nmos W=0.3u L=0.13u
MMR_5_33 RBL[33] RWL[5] MID_5_33 GND sg13_lv_nmos W=0.3u L=0.13u
MMW_5_34 WBL[34] WWL[5] SN_5_34 GND sg13_hv_nmos W=0.15u L=0.45u
MMS_5_34 MID_5_34 SN_5_34 GND GND sg13_lv_nmos W=0.3u L=0.13u
MMR_5_34 RBL[34] RWL[5] MID_5_34 GND sg13_lv_nmos W=0.3u L=0.13u
MMW_5_35 WBL[35] WWL[5] SN_5_35 GND sg13_hv_nmos W=0.15u L=0.45u
MMS_5_35 MID_5_35 SN_5_35 GND GND sg13_lv_nmos W=0.3u L=0.13u
MMR_5_35 RBL[35] RWL[5] MID_5_35 GND sg13_lv_nmos W=0.3u L=0.13u
MMW_5_36 WBL[36] WWL[5] SN_5_36 GND sg13_hv_nmos W=0.15u L=0.45u
MMS_5_36 MID_5_36 SN_5_36 GND GND sg13_lv_nmos W=0.3u L=0.13u
MMR_5_36 RBL[36] RWL[5] MID_5_36 GND sg13_lv_nmos W=0.3u L=0.13u
MMW_5_37 WBL[37] WWL[5] SN_5_37 GND sg13_hv_nmos W=0.15u L=0.45u
MMS_5_37 MID_5_37 SN_5_37 GND GND sg13_lv_nmos W=0.3u L=0.13u
MMR_5_37 RBL[37] RWL[5] MID_5_37 GND sg13_lv_nmos W=0.3u L=0.13u
MMW_6_0 WBL[0] WWL[6] SN_6_0 GND sg13_hv_nmos W=0.15u L=0.45u
MMS_6_0 MID_6_0 SN_6_0 GND GND sg13_lv_nmos W=0.3u L=0.13u
MMR_6_0 RBL[0] RWL[6] MID_6_0 GND sg13_lv_nmos W=0.3u L=0.13u
MMW_6_1 WBL[1] WWL[6] SN_6_1 GND sg13_hv_nmos W=0.15u L=0.45u
MMS_6_1 MID_6_1 SN_6_1 GND GND sg13_lv_nmos W=0.3u L=0.13u
MMR_6_1 RBL[1] RWL[6] MID_6_1 GND sg13_lv_nmos W=0.3u L=0.13u
MMW_6_2 WBL[2] WWL[6] SN_6_2 GND sg13_hv_nmos W=0.15u L=0.45u
MMS_6_2 MID_6_2 SN_6_2 GND GND sg13_lv_nmos W=0.3u L=0.13u
MMR_6_2 RBL[2] RWL[6] MID_6_2 GND sg13_lv_nmos W=0.3u L=0.13u
MMW_6_3 WBL[3] WWL[6] SN_6_3 GND sg13_hv_nmos W=0.15u L=0.45u
MMS_6_3 MID_6_3 SN_6_3 GND GND sg13_lv_nmos W=0.3u L=0.13u
MMR_6_3 RBL[3] RWL[6] MID_6_3 GND sg13_lv_nmos W=0.3u L=0.13u
MMW_6_4 WBL[4] WWL[6] SN_6_4 GND sg13_hv_nmos W=0.15u L=0.45u
MMS_6_4 MID_6_4 SN_6_4 GND GND sg13_lv_nmos W=0.3u L=0.13u
MMR_6_4 RBL[4] RWL[6] MID_6_4 GND sg13_lv_nmos W=0.3u L=0.13u
MMW_6_5 WBL[5] WWL[6] SN_6_5 GND sg13_hv_nmos W=0.15u L=0.45u
MMS_6_5 MID_6_5 SN_6_5 GND GND sg13_lv_nmos W=0.3u L=0.13u
MMR_6_5 RBL[5] RWL[6] MID_6_5 GND sg13_lv_nmos W=0.3u L=0.13u
MMW_6_6 WBL[6] WWL[6] SN_6_6 GND sg13_hv_nmos W=0.15u L=0.45u
MMS_6_6 MID_6_6 SN_6_6 GND GND sg13_lv_nmos W=0.3u L=0.13u
MMR_6_6 RBL[6] RWL[6] MID_6_6 GND sg13_lv_nmos W=0.3u L=0.13u
MMW_6_7 WBL[7] WWL[6] SN_6_7 GND sg13_hv_nmos W=0.15u L=0.45u
MMS_6_7 MID_6_7 SN_6_7 GND GND sg13_lv_nmos W=0.3u L=0.13u
MMR_6_7 RBL[7] RWL[6] MID_6_7 GND sg13_lv_nmos W=0.3u L=0.13u
MMW_6_8 WBL[8] WWL[6] SN_6_8 GND sg13_hv_nmos W=0.15u L=0.45u
MMS_6_8 MID_6_8 SN_6_8 GND GND sg13_lv_nmos W=0.3u L=0.13u
MMR_6_8 RBL[8] RWL[6] MID_6_8 GND sg13_lv_nmos W=0.3u L=0.13u
MMW_6_9 WBL[9] WWL[6] SN_6_9 GND sg13_hv_nmos W=0.15u L=0.45u
MMS_6_9 MID_6_9 SN_6_9 GND GND sg13_lv_nmos W=0.3u L=0.13u
MMR_6_9 RBL[9] RWL[6] MID_6_9 GND sg13_lv_nmos W=0.3u L=0.13u
MMW_6_10 WBL[10] WWL[6] SN_6_10 GND sg13_hv_nmos W=0.15u L=0.45u
MMS_6_10 MID_6_10 SN_6_10 GND GND sg13_lv_nmos W=0.3u L=0.13u
MMR_6_10 RBL[10] RWL[6] MID_6_10 GND sg13_lv_nmos W=0.3u L=0.13u
MMW_6_11 WBL[11] WWL[6] SN_6_11 GND sg13_hv_nmos W=0.15u L=0.45u
MMS_6_11 MID_6_11 SN_6_11 GND GND sg13_lv_nmos W=0.3u L=0.13u
MMR_6_11 RBL[11] RWL[6] MID_6_11 GND sg13_lv_nmos W=0.3u L=0.13u
MMW_6_12 WBL[12] WWL[6] SN_6_12 GND sg13_hv_nmos W=0.15u L=0.45u
MMS_6_12 MID_6_12 SN_6_12 GND GND sg13_lv_nmos W=0.3u L=0.13u
MMR_6_12 RBL[12] RWL[6] MID_6_12 GND sg13_lv_nmos W=0.3u L=0.13u
MMW_6_13 WBL[13] WWL[6] SN_6_13 GND sg13_hv_nmos W=0.15u L=0.45u
MMS_6_13 MID_6_13 SN_6_13 GND GND sg13_lv_nmos W=0.3u L=0.13u
MMR_6_13 RBL[13] RWL[6] MID_6_13 GND sg13_lv_nmos W=0.3u L=0.13u
MMW_6_14 WBL[14] WWL[6] SN_6_14 GND sg13_hv_nmos W=0.15u L=0.45u
MMS_6_14 MID_6_14 SN_6_14 GND GND sg13_lv_nmos W=0.3u L=0.13u
MMR_6_14 RBL[14] RWL[6] MID_6_14 GND sg13_lv_nmos W=0.3u L=0.13u
MMW_6_15 WBL[15] WWL[6] SN_6_15 GND sg13_hv_nmos W=0.15u L=0.45u
MMS_6_15 MID_6_15 SN_6_15 GND GND sg13_lv_nmos W=0.3u L=0.13u
MMR_6_15 RBL[15] RWL[6] MID_6_15 GND sg13_lv_nmos W=0.3u L=0.13u
MMW_6_16 WBL[16] WWL[6] SN_6_16 GND sg13_hv_nmos W=0.15u L=0.45u
MMS_6_16 MID_6_16 SN_6_16 GND GND sg13_lv_nmos W=0.3u L=0.13u
MMR_6_16 RBL[16] RWL[6] MID_6_16 GND sg13_lv_nmos W=0.3u L=0.13u
MMW_6_17 WBL[17] WWL[6] SN_6_17 GND sg13_hv_nmos W=0.15u L=0.45u
MMS_6_17 MID_6_17 SN_6_17 GND GND sg13_lv_nmos W=0.3u L=0.13u
MMR_6_17 RBL[17] RWL[6] MID_6_17 GND sg13_lv_nmos W=0.3u L=0.13u
MMW_6_18 WBL[18] WWL[6] SN_6_18 GND sg13_hv_nmos W=0.15u L=0.45u
MMS_6_18 MID_6_18 SN_6_18 GND GND sg13_lv_nmos W=0.3u L=0.13u
MMR_6_18 RBL[18] RWL[6] MID_6_18 GND sg13_lv_nmos W=0.3u L=0.13u
MMW_6_19 WBL[19] WWL[6] SN_6_19 GND sg13_hv_nmos W=0.15u L=0.45u
MMS_6_19 MID_6_19 SN_6_19 GND GND sg13_lv_nmos W=0.3u L=0.13u
MMR_6_19 RBL[19] RWL[6] MID_6_19 GND sg13_lv_nmos W=0.3u L=0.13u
MMW_6_20 WBL[20] WWL[6] SN_6_20 GND sg13_hv_nmos W=0.15u L=0.45u
MMS_6_20 MID_6_20 SN_6_20 GND GND sg13_lv_nmos W=0.3u L=0.13u
MMR_6_20 RBL[20] RWL[6] MID_6_20 GND sg13_lv_nmos W=0.3u L=0.13u
MMW_6_21 WBL[21] WWL[6] SN_6_21 GND sg13_hv_nmos W=0.15u L=0.45u
MMS_6_21 MID_6_21 SN_6_21 GND GND sg13_lv_nmos W=0.3u L=0.13u
MMR_6_21 RBL[21] RWL[6] MID_6_21 GND sg13_lv_nmos W=0.3u L=0.13u
MMW_6_22 WBL[22] WWL[6] SN_6_22 GND sg13_hv_nmos W=0.15u L=0.45u
MMS_6_22 MID_6_22 SN_6_22 GND GND sg13_lv_nmos W=0.3u L=0.13u
MMR_6_22 RBL[22] RWL[6] MID_6_22 GND sg13_lv_nmos W=0.3u L=0.13u
MMW_6_23 WBL[23] WWL[6] SN_6_23 GND sg13_hv_nmos W=0.15u L=0.45u
MMS_6_23 MID_6_23 SN_6_23 GND GND sg13_lv_nmos W=0.3u L=0.13u
MMR_6_23 RBL[23] RWL[6] MID_6_23 GND sg13_lv_nmos W=0.3u L=0.13u
MMW_6_24 WBL[24] WWL[6] SN_6_24 GND sg13_hv_nmos W=0.15u L=0.45u
MMS_6_24 MID_6_24 SN_6_24 GND GND sg13_lv_nmos W=0.3u L=0.13u
MMR_6_24 RBL[24] RWL[6] MID_6_24 GND sg13_lv_nmos W=0.3u L=0.13u
MMW_6_25 WBL[25] WWL[6] SN_6_25 GND sg13_hv_nmos W=0.15u L=0.45u
MMS_6_25 MID_6_25 SN_6_25 GND GND sg13_lv_nmos W=0.3u L=0.13u
MMR_6_25 RBL[25] RWL[6] MID_6_25 GND sg13_lv_nmos W=0.3u L=0.13u
MMW_6_26 WBL[26] WWL[6] SN_6_26 GND sg13_hv_nmos W=0.15u L=0.45u
MMS_6_26 MID_6_26 SN_6_26 GND GND sg13_lv_nmos W=0.3u L=0.13u
MMR_6_26 RBL[26] RWL[6] MID_6_26 GND sg13_lv_nmos W=0.3u L=0.13u
MMW_6_27 WBL[27] WWL[6] SN_6_27 GND sg13_hv_nmos W=0.15u L=0.45u
MMS_6_27 MID_6_27 SN_6_27 GND GND sg13_lv_nmos W=0.3u L=0.13u
MMR_6_27 RBL[27] RWL[6] MID_6_27 GND sg13_lv_nmos W=0.3u L=0.13u
MMW_6_28 WBL[28] WWL[6] SN_6_28 GND sg13_hv_nmos W=0.15u L=0.45u
MMS_6_28 MID_6_28 SN_6_28 GND GND sg13_lv_nmos W=0.3u L=0.13u
MMR_6_28 RBL[28] RWL[6] MID_6_28 GND sg13_lv_nmos W=0.3u L=0.13u
MMW_6_29 WBL[29] WWL[6] SN_6_29 GND sg13_hv_nmos W=0.15u L=0.45u
MMS_6_29 MID_6_29 SN_6_29 GND GND sg13_lv_nmos W=0.3u L=0.13u
MMR_6_29 RBL[29] RWL[6] MID_6_29 GND sg13_lv_nmos W=0.3u L=0.13u
MMW_6_30 WBL[30] WWL[6] SN_6_30 GND sg13_hv_nmos W=0.15u L=0.45u
MMS_6_30 MID_6_30 SN_6_30 GND GND sg13_lv_nmos W=0.3u L=0.13u
MMR_6_30 RBL[30] RWL[6] MID_6_30 GND sg13_lv_nmos W=0.3u L=0.13u
MMW_6_31 WBL[31] WWL[6] SN_6_31 GND sg13_hv_nmos W=0.15u L=0.45u
MMS_6_31 MID_6_31 SN_6_31 GND GND sg13_lv_nmos W=0.3u L=0.13u
MMR_6_31 RBL[31] RWL[6] MID_6_31 GND sg13_lv_nmos W=0.3u L=0.13u
MMW_6_32 WBL[32] WWL[6] SN_6_32 GND sg13_hv_nmos W=0.15u L=0.45u
MMS_6_32 MID_6_32 SN_6_32 GND GND sg13_lv_nmos W=0.3u L=0.13u
MMR_6_32 RBL[32] RWL[6] MID_6_32 GND sg13_lv_nmos W=0.3u L=0.13u
MMW_6_33 WBL[33] WWL[6] SN_6_33 GND sg13_hv_nmos W=0.15u L=0.45u
MMS_6_33 MID_6_33 SN_6_33 GND GND sg13_lv_nmos W=0.3u L=0.13u
MMR_6_33 RBL[33] RWL[6] MID_6_33 GND sg13_lv_nmos W=0.3u L=0.13u
MMW_6_34 WBL[34] WWL[6] SN_6_34 GND sg13_hv_nmos W=0.15u L=0.45u
MMS_6_34 MID_6_34 SN_6_34 GND GND sg13_lv_nmos W=0.3u L=0.13u
MMR_6_34 RBL[34] RWL[6] MID_6_34 GND sg13_lv_nmos W=0.3u L=0.13u
MMW_6_35 WBL[35] WWL[6] SN_6_35 GND sg13_hv_nmos W=0.15u L=0.45u
MMS_6_35 MID_6_35 SN_6_35 GND GND sg13_lv_nmos W=0.3u L=0.13u
MMR_6_35 RBL[35] RWL[6] MID_6_35 GND sg13_lv_nmos W=0.3u L=0.13u
MMW_6_36 WBL[36] WWL[6] SN_6_36 GND sg13_hv_nmos W=0.15u L=0.45u
MMS_6_36 MID_6_36 SN_6_36 GND GND sg13_lv_nmos W=0.3u L=0.13u
MMR_6_36 RBL[36] RWL[6] MID_6_36 GND sg13_lv_nmos W=0.3u L=0.13u
MMW_6_37 WBL[37] WWL[6] SN_6_37 GND sg13_hv_nmos W=0.15u L=0.45u
MMS_6_37 MID_6_37 SN_6_37 GND GND sg13_lv_nmos W=0.3u L=0.13u
MMR_6_37 RBL[37] RWL[6] MID_6_37 GND sg13_lv_nmos W=0.3u L=0.13u
MMW_7_0 WBL[0] WWL[7] SN_7_0 GND sg13_hv_nmos W=0.15u L=0.45u
MMS_7_0 MID_7_0 SN_7_0 GND GND sg13_lv_nmos W=0.3u L=0.13u
MMR_7_0 RBL[0] RWL[7] MID_7_0 GND sg13_lv_nmos W=0.3u L=0.13u
MMW_7_1 WBL[1] WWL[7] SN_7_1 GND sg13_hv_nmos W=0.15u L=0.45u
MMS_7_1 MID_7_1 SN_7_1 GND GND sg13_lv_nmos W=0.3u L=0.13u
MMR_7_1 RBL[1] RWL[7] MID_7_1 GND sg13_lv_nmos W=0.3u L=0.13u
MMW_7_2 WBL[2] WWL[7] SN_7_2 GND sg13_hv_nmos W=0.15u L=0.45u
MMS_7_2 MID_7_2 SN_7_2 GND GND sg13_lv_nmos W=0.3u L=0.13u
MMR_7_2 RBL[2] RWL[7] MID_7_2 GND sg13_lv_nmos W=0.3u L=0.13u
MMW_7_3 WBL[3] WWL[7] SN_7_3 GND sg13_hv_nmos W=0.15u L=0.45u
MMS_7_3 MID_7_3 SN_7_3 GND GND sg13_lv_nmos W=0.3u L=0.13u
MMR_7_3 RBL[3] RWL[7] MID_7_3 GND sg13_lv_nmos W=0.3u L=0.13u
MMW_7_4 WBL[4] WWL[7] SN_7_4 GND sg13_hv_nmos W=0.15u L=0.45u
MMS_7_4 MID_7_4 SN_7_4 GND GND sg13_lv_nmos W=0.3u L=0.13u
MMR_7_4 RBL[4] RWL[7] MID_7_4 GND sg13_lv_nmos W=0.3u L=0.13u
MMW_7_5 WBL[5] WWL[7] SN_7_5 GND sg13_hv_nmos W=0.15u L=0.45u
MMS_7_5 MID_7_5 SN_7_5 GND GND sg13_lv_nmos W=0.3u L=0.13u
MMR_7_5 RBL[5] RWL[7] MID_7_5 GND sg13_lv_nmos W=0.3u L=0.13u
MMW_7_6 WBL[6] WWL[7] SN_7_6 GND sg13_hv_nmos W=0.15u L=0.45u
MMS_7_6 MID_7_6 SN_7_6 GND GND sg13_lv_nmos W=0.3u L=0.13u
MMR_7_6 RBL[6] RWL[7] MID_7_6 GND sg13_lv_nmos W=0.3u L=0.13u
MMW_7_7 WBL[7] WWL[7] SN_7_7 GND sg13_hv_nmos W=0.15u L=0.45u
MMS_7_7 MID_7_7 SN_7_7 GND GND sg13_lv_nmos W=0.3u L=0.13u
MMR_7_7 RBL[7] RWL[7] MID_7_7 GND sg13_lv_nmos W=0.3u L=0.13u
MMW_7_8 WBL[8] WWL[7] SN_7_8 GND sg13_hv_nmos W=0.15u L=0.45u
MMS_7_8 MID_7_8 SN_7_8 GND GND sg13_lv_nmos W=0.3u L=0.13u
MMR_7_8 RBL[8] RWL[7] MID_7_8 GND sg13_lv_nmos W=0.3u L=0.13u
MMW_7_9 WBL[9] WWL[7] SN_7_9 GND sg13_hv_nmos W=0.15u L=0.45u
MMS_7_9 MID_7_9 SN_7_9 GND GND sg13_lv_nmos W=0.3u L=0.13u
MMR_7_9 RBL[9] RWL[7] MID_7_9 GND sg13_lv_nmos W=0.3u L=0.13u
MMW_7_10 WBL[10] WWL[7] SN_7_10 GND sg13_hv_nmos W=0.15u L=0.45u
MMS_7_10 MID_7_10 SN_7_10 GND GND sg13_lv_nmos W=0.3u L=0.13u
MMR_7_10 RBL[10] RWL[7] MID_7_10 GND sg13_lv_nmos W=0.3u L=0.13u
MMW_7_11 WBL[11] WWL[7] SN_7_11 GND sg13_hv_nmos W=0.15u L=0.45u
MMS_7_11 MID_7_11 SN_7_11 GND GND sg13_lv_nmos W=0.3u L=0.13u
MMR_7_11 RBL[11] RWL[7] MID_7_11 GND sg13_lv_nmos W=0.3u L=0.13u
MMW_7_12 WBL[12] WWL[7] SN_7_12 GND sg13_hv_nmos W=0.15u L=0.45u
MMS_7_12 MID_7_12 SN_7_12 GND GND sg13_lv_nmos W=0.3u L=0.13u
MMR_7_12 RBL[12] RWL[7] MID_7_12 GND sg13_lv_nmos W=0.3u L=0.13u
MMW_7_13 WBL[13] WWL[7] SN_7_13 GND sg13_hv_nmos W=0.15u L=0.45u
MMS_7_13 MID_7_13 SN_7_13 GND GND sg13_lv_nmos W=0.3u L=0.13u
MMR_7_13 RBL[13] RWL[7] MID_7_13 GND sg13_lv_nmos W=0.3u L=0.13u
MMW_7_14 WBL[14] WWL[7] SN_7_14 GND sg13_hv_nmos W=0.15u L=0.45u
MMS_7_14 MID_7_14 SN_7_14 GND GND sg13_lv_nmos W=0.3u L=0.13u
MMR_7_14 RBL[14] RWL[7] MID_7_14 GND sg13_lv_nmos W=0.3u L=0.13u
MMW_7_15 WBL[15] WWL[7] SN_7_15 GND sg13_hv_nmos W=0.15u L=0.45u
MMS_7_15 MID_7_15 SN_7_15 GND GND sg13_lv_nmos W=0.3u L=0.13u
MMR_7_15 RBL[15] RWL[7] MID_7_15 GND sg13_lv_nmos W=0.3u L=0.13u
MMW_7_16 WBL[16] WWL[7] SN_7_16 GND sg13_hv_nmos W=0.15u L=0.45u
MMS_7_16 MID_7_16 SN_7_16 GND GND sg13_lv_nmos W=0.3u L=0.13u
MMR_7_16 RBL[16] RWL[7] MID_7_16 GND sg13_lv_nmos W=0.3u L=0.13u
MMW_7_17 WBL[17] WWL[7] SN_7_17 GND sg13_hv_nmos W=0.15u L=0.45u
MMS_7_17 MID_7_17 SN_7_17 GND GND sg13_lv_nmos W=0.3u L=0.13u
MMR_7_17 RBL[17] RWL[7] MID_7_17 GND sg13_lv_nmos W=0.3u L=0.13u
MMW_7_18 WBL[18] WWL[7] SN_7_18 GND sg13_hv_nmos W=0.15u L=0.45u
MMS_7_18 MID_7_18 SN_7_18 GND GND sg13_lv_nmos W=0.3u L=0.13u
MMR_7_18 RBL[18] RWL[7] MID_7_18 GND sg13_lv_nmos W=0.3u L=0.13u
MMW_7_19 WBL[19] WWL[7] SN_7_19 GND sg13_hv_nmos W=0.15u L=0.45u
MMS_7_19 MID_7_19 SN_7_19 GND GND sg13_lv_nmos W=0.3u L=0.13u
MMR_7_19 RBL[19] RWL[7] MID_7_19 GND sg13_lv_nmos W=0.3u L=0.13u
MMW_7_20 WBL[20] WWL[7] SN_7_20 GND sg13_hv_nmos W=0.15u L=0.45u
MMS_7_20 MID_7_20 SN_7_20 GND GND sg13_lv_nmos W=0.3u L=0.13u
MMR_7_20 RBL[20] RWL[7] MID_7_20 GND sg13_lv_nmos W=0.3u L=0.13u
MMW_7_21 WBL[21] WWL[7] SN_7_21 GND sg13_hv_nmos W=0.15u L=0.45u
MMS_7_21 MID_7_21 SN_7_21 GND GND sg13_lv_nmos W=0.3u L=0.13u
MMR_7_21 RBL[21] RWL[7] MID_7_21 GND sg13_lv_nmos W=0.3u L=0.13u
MMW_7_22 WBL[22] WWL[7] SN_7_22 GND sg13_hv_nmos W=0.15u L=0.45u
MMS_7_22 MID_7_22 SN_7_22 GND GND sg13_lv_nmos W=0.3u L=0.13u
MMR_7_22 RBL[22] RWL[7] MID_7_22 GND sg13_lv_nmos W=0.3u L=0.13u
MMW_7_23 WBL[23] WWL[7] SN_7_23 GND sg13_hv_nmos W=0.15u L=0.45u
MMS_7_23 MID_7_23 SN_7_23 GND GND sg13_lv_nmos W=0.3u L=0.13u
MMR_7_23 RBL[23] RWL[7] MID_7_23 GND sg13_lv_nmos W=0.3u L=0.13u
MMW_7_24 WBL[24] WWL[7] SN_7_24 GND sg13_hv_nmos W=0.15u L=0.45u
MMS_7_24 MID_7_24 SN_7_24 GND GND sg13_lv_nmos W=0.3u L=0.13u
MMR_7_24 RBL[24] RWL[7] MID_7_24 GND sg13_lv_nmos W=0.3u L=0.13u
MMW_7_25 WBL[25] WWL[7] SN_7_25 GND sg13_hv_nmos W=0.15u L=0.45u
MMS_7_25 MID_7_25 SN_7_25 GND GND sg13_lv_nmos W=0.3u L=0.13u
MMR_7_25 RBL[25] RWL[7] MID_7_25 GND sg13_lv_nmos W=0.3u L=0.13u
MMW_7_26 WBL[26] WWL[7] SN_7_26 GND sg13_hv_nmos W=0.15u L=0.45u
MMS_7_26 MID_7_26 SN_7_26 GND GND sg13_lv_nmos W=0.3u L=0.13u
MMR_7_26 RBL[26] RWL[7] MID_7_26 GND sg13_lv_nmos W=0.3u L=0.13u
MMW_7_27 WBL[27] WWL[7] SN_7_27 GND sg13_hv_nmos W=0.15u L=0.45u
MMS_7_27 MID_7_27 SN_7_27 GND GND sg13_lv_nmos W=0.3u L=0.13u
MMR_7_27 RBL[27] RWL[7] MID_7_27 GND sg13_lv_nmos W=0.3u L=0.13u
MMW_7_28 WBL[28] WWL[7] SN_7_28 GND sg13_hv_nmos W=0.15u L=0.45u
MMS_7_28 MID_7_28 SN_7_28 GND GND sg13_lv_nmos W=0.3u L=0.13u
MMR_7_28 RBL[28] RWL[7] MID_7_28 GND sg13_lv_nmos W=0.3u L=0.13u
MMW_7_29 WBL[29] WWL[7] SN_7_29 GND sg13_hv_nmos W=0.15u L=0.45u
MMS_7_29 MID_7_29 SN_7_29 GND GND sg13_lv_nmos W=0.3u L=0.13u
MMR_7_29 RBL[29] RWL[7] MID_7_29 GND sg13_lv_nmos W=0.3u L=0.13u
MMW_7_30 WBL[30] WWL[7] SN_7_30 GND sg13_hv_nmos W=0.15u L=0.45u
MMS_7_30 MID_7_30 SN_7_30 GND GND sg13_lv_nmos W=0.3u L=0.13u
MMR_7_30 RBL[30] RWL[7] MID_7_30 GND sg13_lv_nmos W=0.3u L=0.13u
MMW_7_31 WBL[31] WWL[7] SN_7_31 GND sg13_hv_nmos W=0.15u L=0.45u
MMS_7_31 MID_7_31 SN_7_31 GND GND sg13_lv_nmos W=0.3u L=0.13u
MMR_7_31 RBL[31] RWL[7] MID_7_31 GND sg13_lv_nmos W=0.3u L=0.13u
MMW_7_32 WBL[32] WWL[7] SN_7_32 GND sg13_hv_nmos W=0.15u L=0.45u
MMS_7_32 MID_7_32 SN_7_32 GND GND sg13_lv_nmos W=0.3u L=0.13u
MMR_7_32 RBL[32] RWL[7] MID_7_32 GND sg13_lv_nmos W=0.3u L=0.13u
MMW_7_33 WBL[33] WWL[7] SN_7_33 GND sg13_hv_nmos W=0.15u L=0.45u
MMS_7_33 MID_7_33 SN_7_33 GND GND sg13_lv_nmos W=0.3u L=0.13u
MMR_7_33 RBL[33] RWL[7] MID_7_33 GND sg13_lv_nmos W=0.3u L=0.13u
MMW_7_34 WBL[34] WWL[7] SN_7_34 GND sg13_hv_nmos W=0.15u L=0.45u
MMS_7_34 MID_7_34 SN_7_34 GND GND sg13_lv_nmos W=0.3u L=0.13u
MMR_7_34 RBL[34] RWL[7] MID_7_34 GND sg13_lv_nmos W=0.3u L=0.13u
MMW_7_35 WBL[35] WWL[7] SN_7_35 GND sg13_hv_nmos W=0.15u L=0.45u
MMS_7_35 MID_7_35 SN_7_35 GND GND sg13_lv_nmos W=0.3u L=0.13u
MMR_7_35 RBL[35] RWL[7] MID_7_35 GND sg13_lv_nmos W=0.3u L=0.13u
MMW_7_36 WBL[36] WWL[7] SN_7_36 GND sg13_hv_nmos W=0.15u L=0.45u
MMS_7_36 MID_7_36 SN_7_36 GND GND sg13_lv_nmos W=0.3u L=0.13u
MMR_7_36 RBL[36] RWL[7] MID_7_36 GND sg13_lv_nmos W=0.3u L=0.13u
MMW_7_37 WBL[37] WWL[7] SN_7_37 GND sg13_hv_nmos W=0.15u L=0.45u
MMS_7_37 MID_7_37 SN_7_37 GND GND sg13_lv_nmos W=0.3u L=0.13u
MMR_7_37 RBL[37] RWL[7] MID_7_37 GND sg13_lv_nmos W=0.3u L=0.13u
MMW_8_0 WBL[0] WWL[8] SN_8_0 GND sg13_hv_nmos W=0.15u L=0.45u
MMS_8_0 MID_8_0 SN_8_0 GND GND sg13_lv_nmos W=0.3u L=0.13u
MMR_8_0 RBL[0] RWL[8] MID_8_0 GND sg13_lv_nmos W=0.3u L=0.13u
MMW_8_1 WBL[1] WWL[8] SN_8_1 GND sg13_hv_nmos W=0.15u L=0.45u
MMS_8_1 MID_8_1 SN_8_1 GND GND sg13_lv_nmos W=0.3u L=0.13u
MMR_8_1 RBL[1] RWL[8] MID_8_1 GND sg13_lv_nmos W=0.3u L=0.13u
MMW_8_2 WBL[2] WWL[8] SN_8_2 GND sg13_hv_nmos W=0.15u L=0.45u
MMS_8_2 MID_8_2 SN_8_2 GND GND sg13_lv_nmos W=0.3u L=0.13u
MMR_8_2 RBL[2] RWL[8] MID_8_2 GND sg13_lv_nmos W=0.3u L=0.13u
MMW_8_3 WBL[3] WWL[8] SN_8_3 GND sg13_hv_nmos W=0.15u L=0.45u
MMS_8_3 MID_8_3 SN_8_3 GND GND sg13_lv_nmos W=0.3u L=0.13u
MMR_8_3 RBL[3] RWL[8] MID_8_3 GND sg13_lv_nmos W=0.3u L=0.13u
MMW_8_4 WBL[4] WWL[8] SN_8_4 GND sg13_hv_nmos W=0.15u L=0.45u
MMS_8_4 MID_8_4 SN_8_4 GND GND sg13_lv_nmos W=0.3u L=0.13u
MMR_8_4 RBL[4] RWL[8] MID_8_4 GND sg13_lv_nmos W=0.3u L=0.13u
MMW_8_5 WBL[5] WWL[8] SN_8_5 GND sg13_hv_nmos W=0.15u L=0.45u
MMS_8_5 MID_8_5 SN_8_5 GND GND sg13_lv_nmos W=0.3u L=0.13u
MMR_8_5 RBL[5] RWL[8] MID_8_5 GND sg13_lv_nmos W=0.3u L=0.13u
MMW_8_6 WBL[6] WWL[8] SN_8_6 GND sg13_hv_nmos W=0.15u L=0.45u
MMS_8_6 MID_8_6 SN_8_6 GND GND sg13_lv_nmos W=0.3u L=0.13u
MMR_8_6 RBL[6] RWL[8] MID_8_6 GND sg13_lv_nmos W=0.3u L=0.13u
MMW_8_7 WBL[7] WWL[8] SN_8_7 GND sg13_hv_nmos W=0.15u L=0.45u
MMS_8_7 MID_8_7 SN_8_7 GND GND sg13_lv_nmos W=0.3u L=0.13u
MMR_8_7 RBL[7] RWL[8] MID_8_7 GND sg13_lv_nmos W=0.3u L=0.13u
MMW_8_8 WBL[8] WWL[8] SN_8_8 GND sg13_hv_nmos W=0.15u L=0.45u
MMS_8_8 MID_8_8 SN_8_8 GND GND sg13_lv_nmos W=0.3u L=0.13u
MMR_8_8 RBL[8] RWL[8] MID_8_8 GND sg13_lv_nmos W=0.3u L=0.13u
MMW_8_9 WBL[9] WWL[8] SN_8_9 GND sg13_hv_nmos W=0.15u L=0.45u
MMS_8_9 MID_8_9 SN_8_9 GND GND sg13_lv_nmos W=0.3u L=0.13u
MMR_8_9 RBL[9] RWL[8] MID_8_9 GND sg13_lv_nmos W=0.3u L=0.13u
MMW_8_10 WBL[10] WWL[8] SN_8_10 GND sg13_hv_nmos W=0.15u L=0.45u
MMS_8_10 MID_8_10 SN_8_10 GND GND sg13_lv_nmos W=0.3u L=0.13u
MMR_8_10 RBL[10] RWL[8] MID_8_10 GND sg13_lv_nmos W=0.3u L=0.13u
MMW_8_11 WBL[11] WWL[8] SN_8_11 GND sg13_hv_nmos W=0.15u L=0.45u
MMS_8_11 MID_8_11 SN_8_11 GND GND sg13_lv_nmos W=0.3u L=0.13u
MMR_8_11 RBL[11] RWL[8] MID_8_11 GND sg13_lv_nmos W=0.3u L=0.13u
MMW_8_12 WBL[12] WWL[8] SN_8_12 GND sg13_hv_nmos W=0.15u L=0.45u
MMS_8_12 MID_8_12 SN_8_12 GND GND sg13_lv_nmos W=0.3u L=0.13u
MMR_8_12 RBL[12] RWL[8] MID_8_12 GND sg13_lv_nmos W=0.3u L=0.13u
MMW_8_13 WBL[13] WWL[8] SN_8_13 GND sg13_hv_nmos W=0.15u L=0.45u
MMS_8_13 MID_8_13 SN_8_13 GND GND sg13_lv_nmos W=0.3u L=0.13u
MMR_8_13 RBL[13] RWL[8] MID_8_13 GND sg13_lv_nmos W=0.3u L=0.13u
MMW_8_14 WBL[14] WWL[8] SN_8_14 GND sg13_hv_nmos W=0.15u L=0.45u
MMS_8_14 MID_8_14 SN_8_14 GND GND sg13_lv_nmos W=0.3u L=0.13u
MMR_8_14 RBL[14] RWL[8] MID_8_14 GND sg13_lv_nmos W=0.3u L=0.13u
MMW_8_15 WBL[15] WWL[8] SN_8_15 GND sg13_hv_nmos W=0.15u L=0.45u
MMS_8_15 MID_8_15 SN_8_15 GND GND sg13_lv_nmos W=0.3u L=0.13u
MMR_8_15 RBL[15] RWL[8] MID_8_15 GND sg13_lv_nmos W=0.3u L=0.13u
MMW_8_16 WBL[16] WWL[8] SN_8_16 GND sg13_hv_nmos W=0.15u L=0.45u
MMS_8_16 MID_8_16 SN_8_16 GND GND sg13_lv_nmos W=0.3u L=0.13u
MMR_8_16 RBL[16] RWL[8] MID_8_16 GND sg13_lv_nmos W=0.3u L=0.13u
MMW_8_17 WBL[17] WWL[8] SN_8_17 GND sg13_hv_nmos W=0.15u L=0.45u
MMS_8_17 MID_8_17 SN_8_17 GND GND sg13_lv_nmos W=0.3u L=0.13u
MMR_8_17 RBL[17] RWL[8] MID_8_17 GND sg13_lv_nmos W=0.3u L=0.13u
MMW_8_18 WBL[18] WWL[8] SN_8_18 GND sg13_hv_nmos W=0.15u L=0.45u
MMS_8_18 MID_8_18 SN_8_18 GND GND sg13_lv_nmos W=0.3u L=0.13u
MMR_8_18 RBL[18] RWL[8] MID_8_18 GND sg13_lv_nmos W=0.3u L=0.13u
MMW_8_19 WBL[19] WWL[8] SN_8_19 GND sg13_hv_nmos W=0.15u L=0.45u
MMS_8_19 MID_8_19 SN_8_19 GND GND sg13_lv_nmos W=0.3u L=0.13u
MMR_8_19 RBL[19] RWL[8] MID_8_19 GND sg13_lv_nmos W=0.3u L=0.13u
MMW_8_20 WBL[20] WWL[8] SN_8_20 GND sg13_hv_nmos W=0.15u L=0.45u
MMS_8_20 MID_8_20 SN_8_20 GND GND sg13_lv_nmos W=0.3u L=0.13u
MMR_8_20 RBL[20] RWL[8] MID_8_20 GND sg13_lv_nmos W=0.3u L=0.13u
MMW_8_21 WBL[21] WWL[8] SN_8_21 GND sg13_hv_nmos W=0.15u L=0.45u
MMS_8_21 MID_8_21 SN_8_21 GND GND sg13_lv_nmos W=0.3u L=0.13u
MMR_8_21 RBL[21] RWL[8] MID_8_21 GND sg13_lv_nmos W=0.3u L=0.13u
MMW_8_22 WBL[22] WWL[8] SN_8_22 GND sg13_hv_nmos W=0.15u L=0.45u
MMS_8_22 MID_8_22 SN_8_22 GND GND sg13_lv_nmos W=0.3u L=0.13u
MMR_8_22 RBL[22] RWL[8] MID_8_22 GND sg13_lv_nmos W=0.3u L=0.13u
MMW_8_23 WBL[23] WWL[8] SN_8_23 GND sg13_hv_nmos W=0.15u L=0.45u
MMS_8_23 MID_8_23 SN_8_23 GND GND sg13_lv_nmos W=0.3u L=0.13u
MMR_8_23 RBL[23] RWL[8] MID_8_23 GND sg13_lv_nmos W=0.3u L=0.13u
MMW_8_24 WBL[24] WWL[8] SN_8_24 GND sg13_hv_nmos W=0.15u L=0.45u
MMS_8_24 MID_8_24 SN_8_24 GND GND sg13_lv_nmos W=0.3u L=0.13u
MMR_8_24 RBL[24] RWL[8] MID_8_24 GND sg13_lv_nmos W=0.3u L=0.13u
MMW_8_25 WBL[25] WWL[8] SN_8_25 GND sg13_hv_nmos W=0.15u L=0.45u
MMS_8_25 MID_8_25 SN_8_25 GND GND sg13_lv_nmos W=0.3u L=0.13u
MMR_8_25 RBL[25] RWL[8] MID_8_25 GND sg13_lv_nmos W=0.3u L=0.13u
MMW_8_26 WBL[26] WWL[8] SN_8_26 GND sg13_hv_nmos W=0.15u L=0.45u
MMS_8_26 MID_8_26 SN_8_26 GND GND sg13_lv_nmos W=0.3u L=0.13u
MMR_8_26 RBL[26] RWL[8] MID_8_26 GND sg13_lv_nmos W=0.3u L=0.13u
MMW_8_27 WBL[27] WWL[8] SN_8_27 GND sg13_hv_nmos W=0.15u L=0.45u
MMS_8_27 MID_8_27 SN_8_27 GND GND sg13_lv_nmos W=0.3u L=0.13u
MMR_8_27 RBL[27] RWL[8] MID_8_27 GND sg13_lv_nmos W=0.3u L=0.13u
MMW_8_28 WBL[28] WWL[8] SN_8_28 GND sg13_hv_nmos W=0.15u L=0.45u
MMS_8_28 MID_8_28 SN_8_28 GND GND sg13_lv_nmos W=0.3u L=0.13u
MMR_8_28 RBL[28] RWL[8] MID_8_28 GND sg13_lv_nmos W=0.3u L=0.13u
MMW_8_29 WBL[29] WWL[8] SN_8_29 GND sg13_hv_nmos W=0.15u L=0.45u
MMS_8_29 MID_8_29 SN_8_29 GND GND sg13_lv_nmos W=0.3u L=0.13u
MMR_8_29 RBL[29] RWL[8] MID_8_29 GND sg13_lv_nmos W=0.3u L=0.13u
MMW_8_30 WBL[30] WWL[8] SN_8_30 GND sg13_hv_nmos W=0.15u L=0.45u
MMS_8_30 MID_8_30 SN_8_30 GND GND sg13_lv_nmos W=0.3u L=0.13u
MMR_8_30 RBL[30] RWL[8] MID_8_30 GND sg13_lv_nmos W=0.3u L=0.13u
MMW_8_31 WBL[31] WWL[8] SN_8_31 GND sg13_hv_nmos W=0.15u L=0.45u
MMS_8_31 MID_8_31 SN_8_31 GND GND sg13_lv_nmos W=0.3u L=0.13u
MMR_8_31 RBL[31] RWL[8] MID_8_31 GND sg13_lv_nmos W=0.3u L=0.13u
MMW_8_32 WBL[32] WWL[8] SN_8_32 GND sg13_hv_nmos W=0.15u L=0.45u
MMS_8_32 MID_8_32 SN_8_32 GND GND sg13_lv_nmos W=0.3u L=0.13u
MMR_8_32 RBL[32] RWL[8] MID_8_32 GND sg13_lv_nmos W=0.3u L=0.13u
MMW_8_33 WBL[33] WWL[8] SN_8_33 GND sg13_hv_nmos W=0.15u L=0.45u
MMS_8_33 MID_8_33 SN_8_33 GND GND sg13_lv_nmos W=0.3u L=0.13u
MMR_8_33 RBL[33] RWL[8] MID_8_33 GND sg13_lv_nmos W=0.3u L=0.13u
MMW_8_34 WBL[34] WWL[8] SN_8_34 GND sg13_hv_nmos W=0.15u L=0.45u
MMS_8_34 MID_8_34 SN_8_34 GND GND sg13_lv_nmos W=0.3u L=0.13u
MMR_8_34 RBL[34] RWL[8] MID_8_34 GND sg13_lv_nmos W=0.3u L=0.13u
MMW_8_35 WBL[35] WWL[8] SN_8_35 GND sg13_hv_nmos W=0.15u L=0.45u
MMS_8_35 MID_8_35 SN_8_35 GND GND sg13_lv_nmos W=0.3u L=0.13u
MMR_8_35 RBL[35] RWL[8] MID_8_35 GND sg13_lv_nmos W=0.3u L=0.13u
MMW_8_36 WBL[36] WWL[8] SN_8_36 GND sg13_hv_nmos W=0.15u L=0.45u
MMS_8_36 MID_8_36 SN_8_36 GND GND sg13_lv_nmos W=0.3u L=0.13u
MMR_8_36 RBL[36] RWL[8] MID_8_36 GND sg13_lv_nmos W=0.3u L=0.13u
MMW_8_37 WBL[37] WWL[8] SN_8_37 GND sg13_hv_nmos W=0.15u L=0.45u
MMS_8_37 MID_8_37 SN_8_37 GND GND sg13_lv_nmos W=0.3u L=0.13u
MMR_8_37 RBL[37] RWL[8] MID_8_37 GND sg13_lv_nmos W=0.3u L=0.13u
MMW_9_0 WBL[0] WWL[9] SN_9_0 GND sg13_hv_nmos W=0.15u L=0.45u
MMS_9_0 MID_9_0 SN_9_0 GND GND sg13_lv_nmos W=0.3u L=0.13u
MMR_9_0 RBL[0] RWL[9] MID_9_0 GND sg13_lv_nmos W=0.3u L=0.13u
MMW_9_1 WBL[1] WWL[9] SN_9_1 GND sg13_hv_nmos W=0.15u L=0.45u
MMS_9_1 MID_9_1 SN_9_1 GND GND sg13_lv_nmos W=0.3u L=0.13u
MMR_9_1 RBL[1] RWL[9] MID_9_1 GND sg13_lv_nmos W=0.3u L=0.13u
MMW_9_2 WBL[2] WWL[9] SN_9_2 GND sg13_hv_nmos W=0.15u L=0.45u
MMS_9_2 MID_9_2 SN_9_2 GND GND sg13_lv_nmos W=0.3u L=0.13u
MMR_9_2 RBL[2] RWL[9] MID_9_2 GND sg13_lv_nmos W=0.3u L=0.13u
MMW_9_3 WBL[3] WWL[9] SN_9_3 GND sg13_hv_nmos W=0.15u L=0.45u
MMS_9_3 MID_9_3 SN_9_3 GND GND sg13_lv_nmos W=0.3u L=0.13u
MMR_9_3 RBL[3] RWL[9] MID_9_3 GND sg13_lv_nmos W=0.3u L=0.13u
MMW_9_4 WBL[4] WWL[9] SN_9_4 GND sg13_hv_nmos W=0.15u L=0.45u
MMS_9_4 MID_9_4 SN_9_4 GND GND sg13_lv_nmos W=0.3u L=0.13u
MMR_9_4 RBL[4] RWL[9] MID_9_4 GND sg13_lv_nmos W=0.3u L=0.13u
MMW_9_5 WBL[5] WWL[9] SN_9_5 GND sg13_hv_nmos W=0.15u L=0.45u
MMS_9_5 MID_9_5 SN_9_5 GND GND sg13_lv_nmos W=0.3u L=0.13u
MMR_9_5 RBL[5] RWL[9] MID_9_5 GND sg13_lv_nmos W=0.3u L=0.13u
MMW_9_6 WBL[6] WWL[9] SN_9_6 GND sg13_hv_nmos W=0.15u L=0.45u
MMS_9_6 MID_9_6 SN_9_6 GND GND sg13_lv_nmos W=0.3u L=0.13u
MMR_9_6 RBL[6] RWL[9] MID_9_6 GND sg13_lv_nmos W=0.3u L=0.13u
MMW_9_7 WBL[7] WWL[9] SN_9_7 GND sg13_hv_nmos W=0.15u L=0.45u
MMS_9_7 MID_9_7 SN_9_7 GND GND sg13_lv_nmos W=0.3u L=0.13u
MMR_9_7 RBL[7] RWL[9] MID_9_7 GND sg13_lv_nmos W=0.3u L=0.13u
MMW_9_8 WBL[8] WWL[9] SN_9_8 GND sg13_hv_nmos W=0.15u L=0.45u
MMS_9_8 MID_9_8 SN_9_8 GND GND sg13_lv_nmos W=0.3u L=0.13u
MMR_9_8 RBL[8] RWL[9] MID_9_8 GND sg13_lv_nmos W=0.3u L=0.13u
MMW_9_9 WBL[9] WWL[9] SN_9_9 GND sg13_hv_nmos W=0.15u L=0.45u
MMS_9_9 MID_9_9 SN_9_9 GND GND sg13_lv_nmos W=0.3u L=0.13u
MMR_9_9 RBL[9] RWL[9] MID_9_9 GND sg13_lv_nmos W=0.3u L=0.13u
MMW_9_10 WBL[10] WWL[9] SN_9_10 GND sg13_hv_nmos W=0.15u L=0.45u
MMS_9_10 MID_9_10 SN_9_10 GND GND sg13_lv_nmos W=0.3u L=0.13u
MMR_9_10 RBL[10] RWL[9] MID_9_10 GND sg13_lv_nmos W=0.3u L=0.13u
MMW_9_11 WBL[11] WWL[9] SN_9_11 GND sg13_hv_nmos W=0.15u L=0.45u
MMS_9_11 MID_9_11 SN_9_11 GND GND sg13_lv_nmos W=0.3u L=0.13u
MMR_9_11 RBL[11] RWL[9] MID_9_11 GND sg13_lv_nmos W=0.3u L=0.13u
MMW_9_12 WBL[12] WWL[9] SN_9_12 GND sg13_hv_nmos W=0.15u L=0.45u
MMS_9_12 MID_9_12 SN_9_12 GND GND sg13_lv_nmos W=0.3u L=0.13u
MMR_9_12 RBL[12] RWL[9] MID_9_12 GND sg13_lv_nmos W=0.3u L=0.13u
MMW_9_13 WBL[13] WWL[9] SN_9_13 GND sg13_hv_nmos W=0.15u L=0.45u
MMS_9_13 MID_9_13 SN_9_13 GND GND sg13_lv_nmos W=0.3u L=0.13u
MMR_9_13 RBL[13] RWL[9] MID_9_13 GND sg13_lv_nmos W=0.3u L=0.13u
MMW_9_14 WBL[14] WWL[9] SN_9_14 GND sg13_hv_nmos W=0.15u L=0.45u
MMS_9_14 MID_9_14 SN_9_14 GND GND sg13_lv_nmos W=0.3u L=0.13u
MMR_9_14 RBL[14] RWL[9] MID_9_14 GND sg13_lv_nmos W=0.3u L=0.13u
MMW_9_15 WBL[15] WWL[9] SN_9_15 GND sg13_hv_nmos W=0.15u L=0.45u
MMS_9_15 MID_9_15 SN_9_15 GND GND sg13_lv_nmos W=0.3u L=0.13u
MMR_9_15 RBL[15] RWL[9] MID_9_15 GND sg13_lv_nmos W=0.3u L=0.13u
MMW_9_16 WBL[16] WWL[9] SN_9_16 GND sg13_hv_nmos W=0.15u L=0.45u
MMS_9_16 MID_9_16 SN_9_16 GND GND sg13_lv_nmos W=0.3u L=0.13u
MMR_9_16 RBL[16] RWL[9] MID_9_16 GND sg13_lv_nmos W=0.3u L=0.13u
MMW_9_17 WBL[17] WWL[9] SN_9_17 GND sg13_hv_nmos W=0.15u L=0.45u
MMS_9_17 MID_9_17 SN_9_17 GND GND sg13_lv_nmos W=0.3u L=0.13u
MMR_9_17 RBL[17] RWL[9] MID_9_17 GND sg13_lv_nmos W=0.3u L=0.13u
MMW_9_18 WBL[18] WWL[9] SN_9_18 GND sg13_hv_nmos W=0.15u L=0.45u
MMS_9_18 MID_9_18 SN_9_18 GND GND sg13_lv_nmos W=0.3u L=0.13u
MMR_9_18 RBL[18] RWL[9] MID_9_18 GND sg13_lv_nmos W=0.3u L=0.13u
MMW_9_19 WBL[19] WWL[9] SN_9_19 GND sg13_hv_nmos W=0.15u L=0.45u
MMS_9_19 MID_9_19 SN_9_19 GND GND sg13_lv_nmos W=0.3u L=0.13u
MMR_9_19 RBL[19] RWL[9] MID_9_19 GND sg13_lv_nmos W=0.3u L=0.13u
MMW_9_20 WBL[20] WWL[9] SN_9_20 GND sg13_hv_nmos W=0.15u L=0.45u
MMS_9_20 MID_9_20 SN_9_20 GND GND sg13_lv_nmos W=0.3u L=0.13u
MMR_9_20 RBL[20] RWL[9] MID_9_20 GND sg13_lv_nmos W=0.3u L=0.13u
MMW_9_21 WBL[21] WWL[9] SN_9_21 GND sg13_hv_nmos W=0.15u L=0.45u
MMS_9_21 MID_9_21 SN_9_21 GND GND sg13_lv_nmos W=0.3u L=0.13u
MMR_9_21 RBL[21] RWL[9] MID_9_21 GND sg13_lv_nmos W=0.3u L=0.13u
MMW_9_22 WBL[22] WWL[9] SN_9_22 GND sg13_hv_nmos W=0.15u L=0.45u
MMS_9_22 MID_9_22 SN_9_22 GND GND sg13_lv_nmos W=0.3u L=0.13u
MMR_9_22 RBL[22] RWL[9] MID_9_22 GND sg13_lv_nmos W=0.3u L=0.13u
MMW_9_23 WBL[23] WWL[9] SN_9_23 GND sg13_hv_nmos W=0.15u L=0.45u
MMS_9_23 MID_9_23 SN_9_23 GND GND sg13_lv_nmos W=0.3u L=0.13u
MMR_9_23 RBL[23] RWL[9] MID_9_23 GND sg13_lv_nmos W=0.3u L=0.13u
MMW_9_24 WBL[24] WWL[9] SN_9_24 GND sg13_hv_nmos W=0.15u L=0.45u
MMS_9_24 MID_9_24 SN_9_24 GND GND sg13_lv_nmos W=0.3u L=0.13u
MMR_9_24 RBL[24] RWL[9] MID_9_24 GND sg13_lv_nmos W=0.3u L=0.13u
MMW_9_25 WBL[25] WWL[9] SN_9_25 GND sg13_hv_nmos W=0.15u L=0.45u
MMS_9_25 MID_9_25 SN_9_25 GND GND sg13_lv_nmos W=0.3u L=0.13u
MMR_9_25 RBL[25] RWL[9] MID_9_25 GND sg13_lv_nmos W=0.3u L=0.13u
MMW_9_26 WBL[26] WWL[9] SN_9_26 GND sg13_hv_nmos W=0.15u L=0.45u
MMS_9_26 MID_9_26 SN_9_26 GND GND sg13_lv_nmos W=0.3u L=0.13u
MMR_9_26 RBL[26] RWL[9] MID_9_26 GND sg13_lv_nmos W=0.3u L=0.13u
MMW_9_27 WBL[27] WWL[9] SN_9_27 GND sg13_hv_nmos W=0.15u L=0.45u
MMS_9_27 MID_9_27 SN_9_27 GND GND sg13_lv_nmos W=0.3u L=0.13u
MMR_9_27 RBL[27] RWL[9] MID_9_27 GND sg13_lv_nmos W=0.3u L=0.13u
MMW_9_28 WBL[28] WWL[9] SN_9_28 GND sg13_hv_nmos W=0.15u L=0.45u
MMS_9_28 MID_9_28 SN_9_28 GND GND sg13_lv_nmos W=0.3u L=0.13u
MMR_9_28 RBL[28] RWL[9] MID_9_28 GND sg13_lv_nmos W=0.3u L=0.13u
MMW_9_29 WBL[29] WWL[9] SN_9_29 GND sg13_hv_nmos W=0.15u L=0.45u
MMS_9_29 MID_9_29 SN_9_29 GND GND sg13_lv_nmos W=0.3u L=0.13u
MMR_9_29 RBL[29] RWL[9] MID_9_29 GND sg13_lv_nmos W=0.3u L=0.13u
MMW_9_30 WBL[30] WWL[9] SN_9_30 GND sg13_hv_nmos W=0.15u L=0.45u
MMS_9_30 MID_9_30 SN_9_30 GND GND sg13_lv_nmos W=0.3u L=0.13u
MMR_9_30 RBL[30] RWL[9] MID_9_30 GND sg13_lv_nmos W=0.3u L=0.13u
MMW_9_31 WBL[31] WWL[9] SN_9_31 GND sg13_hv_nmos W=0.15u L=0.45u
MMS_9_31 MID_9_31 SN_9_31 GND GND sg13_lv_nmos W=0.3u L=0.13u
MMR_9_31 RBL[31] RWL[9] MID_9_31 GND sg13_lv_nmos W=0.3u L=0.13u
MMW_9_32 WBL[32] WWL[9] SN_9_32 GND sg13_hv_nmos W=0.15u L=0.45u
MMS_9_32 MID_9_32 SN_9_32 GND GND sg13_lv_nmos W=0.3u L=0.13u
MMR_9_32 RBL[32] RWL[9] MID_9_32 GND sg13_lv_nmos W=0.3u L=0.13u
MMW_9_33 WBL[33] WWL[9] SN_9_33 GND sg13_hv_nmos W=0.15u L=0.45u
MMS_9_33 MID_9_33 SN_9_33 GND GND sg13_lv_nmos W=0.3u L=0.13u
MMR_9_33 RBL[33] RWL[9] MID_9_33 GND sg13_lv_nmos W=0.3u L=0.13u
MMW_9_34 WBL[34] WWL[9] SN_9_34 GND sg13_hv_nmos W=0.15u L=0.45u
MMS_9_34 MID_9_34 SN_9_34 GND GND sg13_lv_nmos W=0.3u L=0.13u
MMR_9_34 RBL[34] RWL[9] MID_9_34 GND sg13_lv_nmos W=0.3u L=0.13u
MMW_9_35 WBL[35] WWL[9] SN_9_35 GND sg13_hv_nmos W=0.15u L=0.45u
MMS_9_35 MID_9_35 SN_9_35 GND GND sg13_lv_nmos W=0.3u L=0.13u
MMR_9_35 RBL[35] RWL[9] MID_9_35 GND sg13_lv_nmos W=0.3u L=0.13u
MMW_9_36 WBL[36] WWL[9] SN_9_36 GND sg13_hv_nmos W=0.15u L=0.45u
MMS_9_36 MID_9_36 SN_9_36 GND GND sg13_lv_nmos W=0.3u L=0.13u
MMR_9_36 RBL[36] RWL[9] MID_9_36 GND sg13_lv_nmos W=0.3u L=0.13u
MMW_9_37 WBL[37] WWL[9] SN_9_37 GND sg13_hv_nmos W=0.15u L=0.45u
MMS_9_37 MID_9_37 SN_9_37 GND GND sg13_lv_nmos W=0.3u L=0.13u
MMR_9_37 RBL[37] RWL[9] MID_9_37 GND sg13_lv_nmos W=0.3u L=0.13u
MMW_10_0 WBL[0] WWL[10] SN_10_0 GND sg13_hv_nmos W=0.15u L=0.45u
MMS_10_0 MID_10_0 SN_10_0 GND GND sg13_lv_nmos W=0.3u L=0.13u
MMR_10_0 RBL[0] RWL[10] MID_10_0 GND sg13_lv_nmos W=0.3u L=0.13u
MMW_10_1 WBL[1] WWL[10] SN_10_1 GND sg13_hv_nmos W=0.15u L=0.45u
MMS_10_1 MID_10_1 SN_10_1 GND GND sg13_lv_nmos W=0.3u L=0.13u
MMR_10_1 RBL[1] RWL[10] MID_10_1 GND sg13_lv_nmos W=0.3u L=0.13u
MMW_10_2 WBL[2] WWL[10] SN_10_2 GND sg13_hv_nmos W=0.15u L=0.45u
MMS_10_2 MID_10_2 SN_10_2 GND GND sg13_lv_nmos W=0.3u L=0.13u
MMR_10_2 RBL[2] RWL[10] MID_10_2 GND sg13_lv_nmos W=0.3u L=0.13u
MMW_10_3 WBL[3] WWL[10] SN_10_3 GND sg13_hv_nmos W=0.15u L=0.45u
MMS_10_3 MID_10_3 SN_10_3 GND GND sg13_lv_nmos W=0.3u L=0.13u
MMR_10_3 RBL[3] RWL[10] MID_10_3 GND sg13_lv_nmos W=0.3u L=0.13u
MMW_10_4 WBL[4] WWL[10] SN_10_4 GND sg13_hv_nmos W=0.15u L=0.45u
MMS_10_4 MID_10_4 SN_10_4 GND GND sg13_lv_nmos W=0.3u L=0.13u
MMR_10_4 RBL[4] RWL[10] MID_10_4 GND sg13_lv_nmos W=0.3u L=0.13u
MMW_10_5 WBL[5] WWL[10] SN_10_5 GND sg13_hv_nmos W=0.15u L=0.45u
MMS_10_5 MID_10_5 SN_10_5 GND GND sg13_lv_nmos W=0.3u L=0.13u
MMR_10_5 RBL[5] RWL[10] MID_10_5 GND sg13_lv_nmos W=0.3u L=0.13u
MMW_10_6 WBL[6] WWL[10] SN_10_6 GND sg13_hv_nmos W=0.15u L=0.45u
MMS_10_6 MID_10_6 SN_10_6 GND GND sg13_lv_nmos W=0.3u L=0.13u
MMR_10_6 RBL[6] RWL[10] MID_10_6 GND sg13_lv_nmos W=0.3u L=0.13u
MMW_10_7 WBL[7] WWL[10] SN_10_7 GND sg13_hv_nmos W=0.15u L=0.45u
MMS_10_7 MID_10_7 SN_10_7 GND GND sg13_lv_nmos W=0.3u L=0.13u
MMR_10_7 RBL[7] RWL[10] MID_10_7 GND sg13_lv_nmos W=0.3u L=0.13u
MMW_10_8 WBL[8] WWL[10] SN_10_8 GND sg13_hv_nmos W=0.15u L=0.45u
MMS_10_8 MID_10_8 SN_10_8 GND GND sg13_lv_nmos W=0.3u L=0.13u
MMR_10_8 RBL[8] RWL[10] MID_10_8 GND sg13_lv_nmos W=0.3u L=0.13u
MMW_10_9 WBL[9] WWL[10] SN_10_9 GND sg13_hv_nmos W=0.15u L=0.45u
MMS_10_9 MID_10_9 SN_10_9 GND GND sg13_lv_nmos W=0.3u L=0.13u
MMR_10_9 RBL[9] RWL[10] MID_10_9 GND sg13_lv_nmos W=0.3u L=0.13u
MMW_10_10 WBL[10] WWL[10] SN_10_10 GND sg13_hv_nmos W=0.15u L=0.45u
MMS_10_10 MID_10_10 SN_10_10 GND GND sg13_lv_nmos W=0.3u L=0.13u
MMR_10_10 RBL[10] RWL[10] MID_10_10 GND sg13_lv_nmos W=0.3u L=0.13u
MMW_10_11 WBL[11] WWL[10] SN_10_11 GND sg13_hv_nmos W=0.15u L=0.45u
MMS_10_11 MID_10_11 SN_10_11 GND GND sg13_lv_nmos W=0.3u L=0.13u
MMR_10_11 RBL[11] RWL[10] MID_10_11 GND sg13_lv_nmos W=0.3u L=0.13u
MMW_10_12 WBL[12] WWL[10] SN_10_12 GND sg13_hv_nmos W=0.15u L=0.45u
MMS_10_12 MID_10_12 SN_10_12 GND GND sg13_lv_nmos W=0.3u L=0.13u
MMR_10_12 RBL[12] RWL[10] MID_10_12 GND sg13_lv_nmos W=0.3u L=0.13u
MMW_10_13 WBL[13] WWL[10] SN_10_13 GND sg13_hv_nmos W=0.15u L=0.45u
MMS_10_13 MID_10_13 SN_10_13 GND GND sg13_lv_nmos W=0.3u L=0.13u
MMR_10_13 RBL[13] RWL[10] MID_10_13 GND sg13_lv_nmos W=0.3u L=0.13u
MMW_10_14 WBL[14] WWL[10] SN_10_14 GND sg13_hv_nmos W=0.15u L=0.45u
MMS_10_14 MID_10_14 SN_10_14 GND GND sg13_lv_nmos W=0.3u L=0.13u
MMR_10_14 RBL[14] RWL[10] MID_10_14 GND sg13_lv_nmos W=0.3u L=0.13u
MMW_10_15 WBL[15] WWL[10] SN_10_15 GND sg13_hv_nmos W=0.15u L=0.45u
MMS_10_15 MID_10_15 SN_10_15 GND GND sg13_lv_nmos W=0.3u L=0.13u
MMR_10_15 RBL[15] RWL[10] MID_10_15 GND sg13_lv_nmos W=0.3u L=0.13u
MMW_10_16 WBL[16] WWL[10] SN_10_16 GND sg13_hv_nmos W=0.15u L=0.45u
MMS_10_16 MID_10_16 SN_10_16 GND GND sg13_lv_nmos W=0.3u L=0.13u
MMR_10_16 RBL[16] RWL[10] MID_10_16 GND sg13_lv_nmos W=0.3u L=0.13u
MMW_10_17 WBL[17] WWL[10] SN_10_17 GND sg13_hv_nmos W=0.15u L=0.45u
MMS_10_17 MID_10_17 SN_10_17 GND GND sg13_lv_nmos W=0.3u L=0.13u
MMR_10_17 RBL[17] RWL[10] MID_10_17 GND sg13_lv_nmos W=0.3u L=0.13u
MMW_10_18 WBL[18] WWL[10] SN_10_18 GND sg13_hv_nmos W=0.15u L=0.45u
MMS_10_18 MID_10_18 SN_10_18 GND GND sg13_lv_nmos W=0.3u L=0.13u
MMR_10_18 RBL[18] RWL[10] MID_10_18 GND sg13_lv_nmos W=0.3u L=0.13u
MMW_10_19 WBL[19] WWL[10] SN_10_19 GND sg13_hv_nmos W=0.15u L=0.45u
MMS_10_19 MID_10_19 SN_10_19 GND GND sg13_lv_nmos W=0.3u L=0.13u
MMR_10_19 RBL[19] RWL[10] MID_10_19 GND sg13_lv_nmos W=0.3u L=0.13u
MMW_10_20 WBL[20] WWL[10] SN_10_20 GND sg13_hv_nmos W=0.15u L=0.45u
MMS_10_20 MID_10_20 SN_10_20 GND GND sg13_lv_nmos W=0.3u L=0.13u
MMR_10_20 RBL[20] RWL[10] MID_10_20 GND sg13_lv_nmos W=0.3u L=0.13u
MMW_10_21 WBL[21] WWL[10] SN_10_21 GND sg13_hv_nmos W=0.15u L=0.45u
MMS_10_21 MID_10_21 SN_10_21 GND GND sg13_lv_nmos W=0.3u L=0.13u
MMR_10_21 RBL[21] RWL[10] MID_10_21 GND sg13_lv_nmos W=0.3u L=0.13u
MMW_10_22 WBL[22] WWL[10] SN_10_22 GND sg13_hv_nmos W=0.15u L=0.45u
MMS_10_22 MID_10_22 SN_10_22 GND GND sg13_lv_nmos W=0.3u L=0.13u
MMR_10_22 RBL[22] RWL[10] MID_10_22 GND sg13_lv_nmos W=0.3u L=0.13u
MMW_10_23 WBL[23] WWL[10] SN_10_23 GND sg13_hv_nmos W=0.15u L=0.45u
MMS_10_23 MID_10_23 SN_10_23 GND GND sg13_lv_nmos W=0.3u L=0.13u
MMR_10_23 RBL[23] RWL[10] MID_10_23 GND sg13_lv_nmos W=0.3u L=0.13u
MMW_10_24 WBL[24] WWL[10] SN_10_24 GND sg13_hv_nmos W=0.15u L=0.45u
MMS_10_24 MID_10_24 SN_10_24 GND GND sg13_lv_nmos W=0.3u L=0.13u
MMR_10_24 RBL[24] RWL[10] MID_10_24 GND sg13_lv_nmos W=0.3u L=0.13u
MMW_10_25 WBL[25] WWL[10] SN_10_25 GND sg13_hv_nmos W=0.15u L=0.45u
MMS_10_25 MID_10_25 SN_10_25 GND GND sg13_lv_nmos W=0.3u L=0.13u
MMR_10_25 RBL[25] RWL[10] MID_10_25 GND sg13_lv_nmos W=0.3u L=0.13u
MMW_10_26 WBL[26] WWL[10] SN_10_26 GND sg13_hv_nmos W=0.15u L=0.45u
MMS_10_26 MID_10_26 SN_10_26 GND GND sg13_lv_nmos W=0.3u L=0.13u
MMR_10_26 RBL[26] RWL[10] MID_10_26 GND sg13_lv_nmos W=0.3u L=0.13u
MMW_10_27 WBL[27] WWL[10] SN_10_27 GND sg13_hv_nmos W=0.15u L=0.45u
MMS_10_27 MID_10_27 SN_10_27 GND GND sg13_lv_nmos W=0.3u L=0.13u
MMR_10_27 RBL[27] RWL[10] MID_10_27 GND sg13_lv_nmos W=0.3u L=0.13u
MMW_10_28 WBL[28] WWL[10] SN_10_28 GND sg13_hv_nmos W=0.15u L=0.45u
MMS_10_28 MID_10_28 SN_10_28 GND GND sg13_lv_nmos W=0.3u L=0.13u
MMR_10_28 RBL[28] RWL[10] MID_10_28 GND sg13_lv_nmos W=0.3u L=0.13u
MMW_10_29 WBL[29] WWL[10] SN_10_29 GND sg13_hv_nmos W=0.15u L=0.45u
MMS_10_29 MID_10_29 SN_10_29 GND GND sg13_lv_nmos W=0.3u L=0.13u
MMR_10_29 RBL[29] RWL[10] MID_10_29 GND sg13_lv_nmos W=0.3u L=0.13u
MMW_10_30 WBL[30] WWL[10] SN_10_30 GND sg13_hv_nmos W=0.15u L=0.45u
MMS_10_30 MID_10_30 SN_10_30 GND GND sg13_lv_nmos W=0.3u L=0.13u
MMR_10_30 RBL[30] RWL[10] MID_10_30 GND sg13_lv_nmos W=0.3u L=0.13u
MMW_10_31 WBL[31] WWL[10] SN_10_31 GND sg13_hv_nmos W=0.15u L=0.45u
MMS_10_31 MID_10_31 SN_10_31 GND GND sg13_lv_nmos W=0.3u L=0.13u
MMR_10_31 RBL[31] RWL[10] MID_10_31 GND sg13_lv_nmos W=0.3u L=0.13u
MMW_10_32 WBL[32] WWL[10] SN_10_32 GND sg13_hv_nmos W=0.15u L=0.45u
MMS_10_32 MID_10_32 SN_10_32 GND GND sg13_lv_nmos W=0.3u L=0.13u
MMR_10_32 RBL[32] RWL[10] MID_10_32 GND sg13_lv_nmos W=0.3u L=0.13u
MMW_10_33 WBL[33] WWL[10] SN_10_33 GND sg13_hv_nmos W=0.15u L=0.45u
MMS_10_33 MID_10_33 SN_10_33 GND GND sg13_lv_nmos W=0.3u L=0.13u
MMR_10_33 RBL[33] RWL[10] MID_10_33 GND sg13_lv_nmos W=0.3u L=0.13u
MMW_10_34 WBL[34] WWL[10] SN_10_34 GND sg13_hv_nmos W=0.15u L=0.45u
MMS_10_34 MID_10_34 SN_10_34 GND GND sg13_lv_nmos W=0.3u L=0.13u
MMR_10_34 RBL[34] RWL[10] MID_10_34 GND sg13_lv_nmos W=0.3u L=0.13u
MMW_10_35 WBL[35] WWL[10] SN_10_35 GND sg13_hv_nmos W=0.15u L=0.45u
MMS_10_35 MID_10_35 SN_10_35 GND GND sg13_lv_nmos W=0.3u L=0.13u
MMR_10_35 RBL[35] RWL[10] MID_10_35 GND sg13_lv_nmos W=0.3u L=0.13u
MMW_10_36 WBL[36] WWL[10] SN_10_36 GND sg13_hv_nmos W=0.15u L=0.45u
MMS_10_36 MID_10_36 SN_10_36 GND GND sg13_lv_nmos W=0.3u L=0.13u
MMR_10_36 RBL[36] RWL[10] MID_10_36 GND sg13_lv_nmos W=0.3u L=0.13u
MMW_10_37 WBL[37] WWL[10] SN_10_37 GND sg13_hv_nmos W=0.15u L=0.45u
MMS_10_37 MID_10_37 SN_10_37 GND GND sg13_lv_nmos W=0.3u L=0.13u
MMR_10_37 RBL[37] RWL[10] MID_10_37 GND sg13_lv_nmos W=0.3u L=0.13u
MMW_11_0 WBL[0] WWL[11] SN_11_0 GND sg13_hv_nmos W=0.15u L=0.45u
MMS_11_0 MID_11_0 SN_11_0 GND GND sg13_lv_nmos W=0.3u L=0.13u
MMR_11_0 RBL[0] RWL[11] MID_11_0 GND sg13_lv_nmos W=0.3u L=0.13u
MMW_11_1 WBL[1] WWL[11] SN_11_1 GND sg13_hv_nmos W=0.15u L=0.45u
MMS_11_1 MID_11_1 SN_11_1 GND GND sg13_lv_nmos W=0.3u L=0.13u
MMR_11_1 RBL[1] RWL[11] MID_11_1 GND sg13_lv_nmos W=0.3u L=0.13u
MMW_11_2 WBL[2] WWL[11] SN_11_2 GND sg13_hv_nmos W=0.15u L=0.45u
MMS_11_2 MID_11_2 SN_11_2 GND GND sg13_lv_nmos W=0.3u L=0.13u
MMR_11_2 RBL[2] RWL[11] MID_11_2 GND sg13_lv_nmos W=0.3u L=0.13u
MMW_11_3 WBL[3] WWL[11] SN_11_3 GND sg13_hv_nmos W=0.15u L=0.45u
MMS_11_3 MID_11_3 SN_11_3 GND GND sg13_lv_nmos W=0.3u L=0.13u
MMR_11_3 RBL[3] RWL[11] MID_11_3 GND sg13_lv_nmos W=0.3u L=0.13u
MMW_11_4 WBL[4] WWL[11] SN_11_4 GND sg13_hv_nmos W=0.15u L=0.45u
MMS_11_4 MID_11_4 SN_11_4 GND GND sg13_lv_nmos W=0.3u L=0.13u
MMR_11_4 RBL[4] RWL[11] MID_11_4 GND sg13_lv_nmos W=0.3u L=0.13u
MMW_11_5 WBL[5] WWL[11] SN_11_5 GND sg13_hv_nmos W=0.15u L=0.45u
MMS_11_5 MID_11_5 SN_11_5 GND GND sg13_lv_nmos W=0.3u L=0.13u
MMR_11_5 RBL[5] RWL[11] MID_11_5 GND sg13_lv_nmos W=0.3u L=0.13u
MMW_11_6 WBL[6] WWL[11] SN_11_6 GND sg13_hv_nmos W=0.15u L=0.45u
MMS_11_6 MID_11_6 SN_11_6 GND GND sg13_lv_nmos W=0.3u L=0.13u
MMR_11_6 RBL[6] RWL[11] MID_11_6 GND sg13_lv_nmos W=0.3u L=0.13u
MMW_11_7 WBL[7] WWL[11] SN_11_7 GND sg13_hv_nmos W=0.15u L=0.45u
MMS_11_7 MID_11_7 SN_11_7 GND GND sg13_lv_nmos W=0.3u L=0.13u
MMR_11_7 RBL[7] RWL[11] MID_11_7 GND sg13_lv_nmos W=0.3u L=0.13u
MMW_11_8 WBL[8] WWL[11] SN_11_8 GND sg13_hv_nmos W=0.15u L=0.45u
MMS_11_8 MID_11_8 SN_11_8 GND GND sg13_lv_nmos W=0.3u L=0.13u
MMR_11_8 RBL[8] RWL[11] MID_11_8 GND sg13_lv_nmos W=0.3u L=0.13u
MMW_11_9 WBL[9] WWL[11] SN_11_9 GND sg13_hv_nmos W=0.15u L=0.45u
MMS_11_9 MID_11_9 SN_11_9 GND GND sg13_lv_nmos W=0.3u L=0.13u
MMR_11_9 RBL[9] RWL[11] MID_11_9 GND sg13_lv_nmos W=0.3u L=0.13u
MMW_11_10 WBL[10] WWL[11] SN_11_10 GND sg13_hv_nmos W=0.15u L=0.45u
MMS_11_10 MID_11_10 SN_11_10 GND GND sg13_lv_nmos W=0.3u L=0.13u
MMR_11_10 RBL[10] RWL[11] MID_11_10 GND sg13_lv_nmos W=0.3u L=0.13u
MMW_11_11 WBL[11] WWL[11] SN_11_11 GND sg13_hv_nmos W=0.15u L=0.45u
MMS_11_11 MID_11_11 SN_11_11 GND GND sg13_lv_nmos W=0.3u L=0.13u
MMR_11_11 RBL[11] RWL[11] MID_11_11 GND sg13_lv_nmos W=0.3u L=0.13u
MMW_11_12 WBL[12] WWL[11] SN_11_12 GND sg13_hv_nmos W=0.15u L=0.45u
MMS_11_12 MID_11_12 SN_11_12 GND GND sg13_lv_nmos W=0.3u L=0.13u
MMR_11_12 RBL[12] RWL[11] MID_11_12 GND sg13_lv_nmos W=0.3u L=0.13u
MMW_11_13 WBL[13] WWL[11] SN_11_13 GND sg13_hv_nmos W=0.15u L=0.45u
MMS_11_13 MID_11_13 SN_11_13 GND GND sg13_lv_nmos W=0.3u L=0.13u
MMR_11_13 RBL[13] RWL[11] MID_11_13 GND sg13_lv_nmos W=0.3u L=0.13u
MMW_11_14 WBL[14] WWL[11] SN_11_14 GND sg13_hv_nmos W=0.15u L=0.45u
MMS_11_14 MID_11_14 SN_11_14 GND GND sg13_lv_nmos W=0.3u L=0.13u
MMR_11_14 RBL[14] RWL[11] MID_11_14 GND sg13_lv_nmos W=0.3u L=0.13u
MMW_11_15 WBL[15] WWL[11] SN_11_15 GND sg13_hv_nmos W=0.15u L=0.45u
MMS_11_15 MID_11_15 SN_11_15 GND GND sg13_lv_nmos W=0.3u L=0.13u
MMR_11_15 RBL[15] RWL[11] MID_11_15 GND sg13_lv_nmos W=0.3u L=0.13u
MMW_11_16 WBL[16] WWL[11] SN_11_16 GND sg13_hv_nmos W=0.15u L=0.45u
MMS_11_16 MID_11_16 SN_11_16 GND GND sg13_lv_nmos W=0.3u L=0.13u
MMR_11_16 RBL[16] RWL[11] MID_11_16 GND sg13_lv_nmos W=0.3u L=0.13u
MMW_11_17 WBL[17] WWL[11] SN_11_17 GND sg13_hv_nmos W=0.15u L=0.45u
MMS_11_17 MID_11_17 SN_11_17 GND GND sg13_lv_nmos W=0.3u L=0.13u
MMR_11_17 RBL[17] RWL[11] MID_11_17 GND sg13_lv_nmos W=0.3u L=0.13u
MMW_11_18 WBL[18] WWL[11] SN_11_18 GND sg13_hv_nmos W=0.15u L=0.45u
MMS_11_18 MID_11_18 SN_11_18 GND GND sg13_lv_nmos W=0.3u L=0.13u
MMR_11_18 RBL[18] RWL[11] MID_11_18 GND sg13_lv_nmos W=0.3u L=0.13u
MMW_11_19 WBL[19] WWL[11] SN_11_19 GND sg13_hv_nmos W=0.15u L=0.45u
MMS_11_19 MID_11_19 SN_11_19 GND GND sg13_lv_nmos W=0.3u L=0.13u
MMR_11_19 RBL[19] RWL[11] MID_11_19 GND sg13_lv_nmos W=0.3u L=0.13u
MMW_11_20 WBL[20] WWL[11] SN_11_20 GND sg13_hv_nmos W=0.15u L=0.45u
MMS_11_20 MID_11_20 SN_11_20 GND GND sg13_lv_nmos W=0.3u L=0.13u
MMR_11_20 RBL[20] RWL[11] MID_11_20 GND sg13_lv_nmos W=0.3u L=0.13u
MMW_11_21 WBL[21] WWL[11] SN_11_21 GND sg13_hv_nmos W=0.15u L=0.45u
MMS_11_21 MID_11_21 SN_11_21 GND GND sg13_lv_nmos W=0.3u L=0.13u
MMR_11_21 RBL[21] RWL[11] MID_11_21 GND sg13_lv_nmos W=0.3u L=0.13u
MMW_11_22 WBL[22] WWL[11] SN_11_22 GND sg13_hv_nmos W=0.15u L=0.45u
MMS_11_22 MID_11_22 SN_11_22 GND GND sg13_lv_nmos W=0.3u L=0.13u
MMR_11_22 RBL[22] RWL[11] MID_11_22 GND sg13_lv_nmos W=0.3u L=0.13u
MMW_11_23 WBL[23] WWL[11] SN_11_23 GND sg13_hv_nmos W=0.15u L=0.45u
MMS_11_23 MID_11_23 SN_11_23 GND GND sg13_lv_nmos W=0.3u L=0.13u
MMR_11_23 RBL[23] RWL[11] MID_11_23 GND sg13_lv_nmos W=0.3u L=0.13u
MMW_11_24 WBL[24] WWL[11] SN_11_24 GND sg13_hv_nmos W=0.15u L=0.45u
MMS_11_24 MID_11_24 SN_11_24 GND GND sg13_lv_nmos W=0.3u L=0.13u
MMR_11_24 RBL[24] RWL[11] MID_11_24 GND sg13_lv_nmos W=0.3u L=0.13u
MMW_11_25 WBL[25] WWL[11] SN_11_25 GND sg13_hv_nmos W=0.15u L=0.45u
MMS_11_25 MID_11_25 SN_11_25 GND GND sg13_lv_nmos W=0.3u L=0.13u
MMR_11_25 RBL[25] RWL[11] MID_11_25 GND sg13_lv_nmos W=0.3u L=0.13u
MMW_11_26 WBL[26] WWL[11] SN_11_26 GND sg13_hv_nmos W=0.15u L=0.45u
MMS_11_26 MID_11_26 SN_11_26 GND GND sg13_lv_nmos W=0.3u L=0.13u
MMR_11_26 RBL[26] RWL[11] MID_11_26 GND sg13_lv_nmos W=0.3u L=0.13u
MMW_11_27 WBL[27] WWL[11] SN_11_27 GND sg13_hv_nmos W=0.15u L=0.45u
MMS_11_27 MID_11_27 SN_11_27 GND GND sg13_lv_nmos W=0.3u L=0.13u
MMR_11_27 RBL[27] RWL[11] MID_11_27 GND sg13_lv_nmos W=0.3u L=0.13u
MMW_11_28 WBL[28] WWL[11] SN_11_28 GND sg13_hv_nmos W=0.15u L=0.45u
MMS_11_28 MID_11_28 SN_11_28 GND GND sg13_lv_nmos W=0.3u L=0.13u
MMR_11_28 RBL[28] RWL[11] MID_11_28 GND sg13_lv_nmos W=0.3u L=0.13u
MMW_11_29 WBL[29] WWL[11] SN_11_29 GND sg13_hv_nmos W=0.15u L=0.45u
MMS_11_29 MID_11_29 SN_11_29 GND GND sg13_lv_nmos W=0.3u L=0.13u
MMR_11_29 RBL[29] RWL[11] MID_11_29 GND sg13_lv_nmos W=0.3u L=0.13u
MMW_11_30 WBL[30] WWL[11] SN_11_30 GND sg13_hv_nmos W=0.15u L=0.45u
MMS_11_30 MID_11_30 SN_11_30 GND GND sg13_lv_nmos W=0.3u L=0.13u
MMR_11_30 RBL[30] RWL[11] MID_11_30 GND sg13_lv_nmos W=0.3u L=0.13u
MMW_11_31 WBL[31] WWL[11] SN_11_31 GND sg13_hv_nmos W=0.15u L=0.45u
MMS_11_31 MID_11_31 SN_11_31 GND GND sg13_lv_nmos W=0.3u L=0.13u
MMR_11_31 RBL[31] RWL[11] MID_11_31 GND sg13_lv_nmos W=0.3u L=0.13u
MMW_11_32 WBL[32] WWL[11] SN_11_32 GND sg13_hv_nmos W=0.15u L=0.45u
MMS_11_32 MID_11_32 SN_11_32 GND GND sg13_lv_nmos W=0.3u L=0.13u
MMR_11_32 RBL[32] RWL[11] MID_11_32 GND sg13_lv_nmos W=0.3u L=0.13u
MMW_11_33 WBL[33] WWL[11] SN_11_33 GND sg13_hv_nmos W=0.15u L=0.45u
MMS_11_33 MID_11_33 SN_11_33 GND GND sg13_lv_nmos W=0.3u L=0.13u
MMR_11_33 RBL[33] RWL[11] MID_11_33 GND sg13_lv_nmos W=0.3u L=0.13u
MMW_11_34 WBL[34] WWL[11] SN_11_34 GND sg13_hv_nmos W=0.15u L=0.45u
MMS_11_34 MID_11_34 SN_11_34 GND GND sg13_lv_nmos W=0.3u L=0.13u
MMR_11_34 RBL[34] RWL[11] MID_11_34 GND sg13_lv_nmos W=0.3u L=0.13u
MMW_11_35 WBL[35] WWL[11] SN_11_35 GND sg13_hv_nmos W=0.15u L=0.45u
MMS_11_35 MID_11_35 SN_11_35 GND GND sg13_lv_nmos W=0.3u L=0.13u
MMR_11_35 RBL[35] RWL[11] MID_11_35 GND sg13_lv_nmos W=0.3u L=0.13u
MMW_11_36 WBL[36] WWL[11] SN_11_36 GND sg13_hv_nmos W=0.15u L=0.45u
MMS_11_36 MID_11_36 SN_11_36 GND GND sg13_lv_nmos W=0.3u L=0.13u
MMR_11_36 RBL[36] RWL[11] MID_11_36 GND sg13_lv_nmos W=0.3u L=0.13u
MMW_11_37 WBL[37] WWL[11] SN_11_37 GND sg13_hv_nmos W=0.15u L=0.45u
MMS_11_37 MID_11_37 SN_11_37 GND GND sg13_lv_nmos W=0.3u L=0.13u
MMR_11_37 RBL[37] RWL[11] MID_11_37 GND sg13_lv_nmos W=0.3u L=0.13u
MMW_12_0 WBL[0] WWL[12] SN_12_0 GND sg13_hv_nmos W=0.15u L=0.45u
MMS_12_0 MID_12_0 SN_12_0 GND GND sg13_lv_nmos W=0.3u L=0.13u
MMR_12_0 RBL[0] RWL[12] MID_12_0 GND sg13_lv_nmos W=0.3u L=0.13u
MMW_12_1 WBL[1] WWL[12] SN_12_1 GND sg13_hv_nmos W=0.15u L=0.45u
MMS_12_1 MID_12_1 SN_12_1 GND GND sg13_lv_nmos W=0.3u L=0.13u
MMR_12_1 RBL[1] RWL[12] MID_12_1 GND sg13_lv_nmos W=0.3u L=0.13u
MMW_12_2 WBL[2] WWL[12] SN_12_2 GND sg13_hv_nmos W=0.15u L=0.45u
MMS_12_2 MID_12_2 SN_12_2 GND GND sg13_lv_nmos W=0.3u L=0.13u
MMR_12_2 RBL[2] RWL[12] MID_12_2 GND sg13_lv_nmos W=0.3u L=0.13u
MMW_12_3 WBL[3] WWL[12] SN_12_3 GND sg13_hv_nmos W=0.15u L=0.45u
MMS_12_3 MID_12_3 SN_12_3 GND GND sg13_lv_nmos W=0.3u L=0.13u
MMR_12_3 RBL[3] RWL[12] MID_12_3 GND sg13_lv_nmos W=0.3u L=0.13u
MMW_12_4 WBL[4] WWL[12] SN_12_4 GND sg13_hv_nmos W=0.15u L=0.45u
MMS_12_4 MID_12_4 SN_12_4 GND GND sg13_lv_nmos W=0.3u L=0.13u
MMR_12_4 RBL[4] RWL[12] MID_12_4 GND sg13_lv_nmos W=0.3u L=0.13u
MMW_12_5 WBL[5] WWL[12] SN_12_5 GND sg13_hv_nmos W=0.15u L=0.45u
MMS_12_5 MID_12_5 SN_12_5 GND GND sg13_lv_nmos W=0.3u L=0.13u
MMR_12_5 RBL[5] RWL[12] MID_12_5 GND sg13_lv_nmos W=0.3u L=0.13u
MMW_12_6 WBL[6] WWL[12] SN_12_6 GND sg13_hv_nmos W=0.15u L=0.45u
MMS_12_6 MID_12_6 SN_12_6 GND GND sg13_lv_nmos W=0.3u L=0.13u
MMR_12_6 RBL[6] RWL[12] MID_12_6 GND sg13_lv_nmos W=0.3u L=0.13u
MMW_12_7 WBL[7] WWL[12] SN_12_7 GND sg13_hv_nmos W=0.15u L=0.45u
MMS_12_7 MID_12_7 SN_12_7 GND GND sg13_lv_nmos W=0.3u L=0.13u
MMR_12_7 RBL[7] RWL[12] MID_12_7 GND sg13_lv_nmos W=0.3u L=0.13u
MMW_12_8 WBL[8] WWL[12] SN_12_8 GND sg13_hv_nmos W=0.15u L=0.45u
MMS_12_8 MID_12_8 SN_12_8 GND GND sg13_lv_nmos W=0.3u L=0.13u
MMR_12_8 RBL[8] RWL[12] MID_12_8 GND sg13_lv_nmos W=0.3u L=0.13u
MMW_12_9 WBL[9] WWL[12] SN_12_9 GND sg13_hv_nmos W=0.15u L=0.45u
MMS_12_9 MID_12_9 SN_12_9 GND GND sg13_lv_nmos W=0.3u L=0.13u
MMR_12_9 RBL[9] RWL[12] MID_12_9 GND sg13_lv_nmos W=0.3u L=0.13u
MMW_12_10 WBL[10] WWL[12] SN_12_10 GND sg13_hv_nmos W=0.15u L=0.45u
MMS_12_10 MID_12_10 SN_12_10 GND GND sg13_lv_nmos W=0.3u L=0.13u
MMR_12_10 RBL[10] RWL[12] MID_12_10 GND sg13_lv_nmos W=0.3u L=0.13u
MMW_12_11 WBL[11] WWL[12] SN_12_11 GND sg13_hv_nmos W=0.15u L=0.45u
MMS_12_11 MID_12_11 SN_12_11 GND GND sg13_lv_nmos W=0.3u L=0.13u
MMR_12_11 RBL[11] RWL[12] MID_12_11 GND sg13_lv_nmos W=0.3u L=0.13u
MMW_12_12 WBL[12] WWL[12] SN_12_12 GND sg13_hv_nmos W=0.15u L=0.45u
MMS_12_12 MID_12_12 SN_12_12 GND GND sg13_lv_nmos W=0.3u L=0.13u
MMR_12_12 RBL[12] RWL[12] MID_12_12 GND sg13_lv_nmos W=0.3u L=0.13u
MMW_12_13 WBL[13] WWL[12] SN_12_13 GND sg13_hv_nmos W=0.15u L=0.45u
MMS_12_13 MID_12_13 SN_12_13 GND GND sg13_lv_nmos W=0.3u L=0.13u
MMR_12_13 RBL[13] RWL[12] MID_12_13 GND sg13_lv_nmos W=0.3u L=0.13u
MMW_12_14 WBL[14] WWL[12] SN_12_14 GND sg13_hv_nmos W=0.15u L=0.45u
MMS_12_14 MID_12_14 SN_12_14 GND GND sg13_lv_nmos W=0.3u L=0.13u
MMR_12_14 RBL[14] RWL[12] MID_12_14 GND sg13_lv_nmos W=0.3u L=0.13u
MMW_12_15 WBL[15] WWL[12] SN_12_15 GND sg13_hv_nmos W=0.15u L=0.45u
MMS_12_15 MID_12_15 SN_12_15 GND GND sg13_lv_nmos W=0.3u L=0.13u
MMR_12_15 RBL[15] RWL[12] MID_12_15 GND sg13_lv_nmos W=0.3u L=0.13u
MMW_12_16 WBL[16] WWL[12] SN_12_16 GND sg13_hv_nmos W=0.15u L=0.45u
MMS_12_16 MID_12_16 SN_12_16 GND GND sg13_lv_nmos W=0.3u L=0.13u
MMR_12_16 RBL[16] RWL[12] MID_12_16 GND sg13_lv_nmos W=0.3u L=0.13u
MMW_12_17 WBL[17] WWL[12] SN_12_17 GND sg13_hv_nmos W=0.15u L=0.45u
MMS_12_17 MID_12_17 SN_12_17 GND GND sg13_lv_nmos W=0.3u L=0.13u
MMR_12_17 RBL[17] RWL[12] MID_12_17 GND sg13_lv_nmos W=0.3u L=0.13u
MMW_12_18 WBL[18] WWL[12] SN_12_18 GND sg13_hv_nmos W=0.15u L=0.45u
MMS_12_18 MID_12_18 SN_12_18 GND GND sg13_lv_nmos W=0.3u L=0.13u
MMR_12_18 RBL[18] RWL[12] MID_12_18 GND sg13_lv_nmos W=0.3u L=0.13u
MMW_12_19 WBL[19] WWL[12] SN_12_19 GND sg13_hv_nmos W=0.15u L=0.45u
MMS_12_19 MID_12_19 SN_12_19 GND GND sg13_lv_nmos W=0.3u L=0.13u
MMR_12_19 RBL[19] RWL[12] MID_12_19 GND sg13_lv_nmos W=0.3u L=0.13u
MMW_12_20 WBL[20] WWL[12] SN_12_20 GND sg13_hv_nmos W=0.15u L=0.45u
MMS_12_20 MID_12_20 SN_12_20 GND GND sg13_lv_nmos W=0.3u L=0.13u
MMR_12_20 RBL[20] RWL[12] MID_12_20 GND sg13_lv_nmos W=0.3u L=0.13u
MMW_12_21 WBL[21] WWL[12] SN_12_21 GND sg13_hv_nmos W=0.15u L=0.45u
MMS_12_21 MID_12_21 SN_12_21 GND GND sg13_lv_nmos W=0.3u L=0.13u
MMR_12_21 RBL[21] RWL[12] MID_12_21 GND sg13_lv_nmos W=0.3u L=0.13u
MMW_12_22 WBL[22] WWL[12] SN_12_22 GND sg13_hv_nmos W=0.15u L=0.45u
MMS_12_22 MID_12_22 SN_12_22 GND GND sg13_lv_nmos W=0.3u L=0.13u
MMR_12_22 RBL[22] RWL[12] MID_12_22 GND sg13_lv_nmos W=0.3u L=0.13u
MMW_12_23 WBL[23] WWL[12] SN_12_23 GND sg13_hv_nmos W=0.15u L=0.45u
MMS_12_23 MID_12_23 SN_12_23 GND GND sg13_lv_nmos W=0.3u L=0.13u
MMR_12_23 RBL[23] RWL[12] MID_12_23 GND sg13_lv_nmos W=0.3u L=0.13u
MMW_12_24 WBL[24] WWL[12] SN_12_24 GND sg13_hv_nmos W=0.15u L=0.45u
MMS_12_24 MID_12_24 SN_12_24 GND GND sg13_lv_nmos W=0.3u L=0.13u
MMR_12_24 RBL[24] RWL[12] MID_12_24 GND sg13_lv_nmos W=0.3u L=0.13u
MMW_12_25 WBL[25] WWL[12] SN_12_25 GND sg13_hv_nmos W=0.15u L=0.45u
MMS_12_25 MID_12_25 SN_12_25 GND GND sg13_lv_nmos W=0.3u L=0.13u
MMR_12_25 RBL[25] RWL[12] MID_12_25 GND sg13_lv_nmos W=0.3u L=0.13u
MMW_12_26 WBL[26] WWL[12] SN_12_26 GND sg13_hv_nmos W=0.15u L=0.45u
MMS_12_26 MID_12_26 SN_12_26 GND GND sg13_lv_nmos W=0.3u L=0.13u
MMR_12_26 RBL[26] RWL[12] MID_12_26 GND sg13_lv_nmos W=0.3u L=0.13u
MMW_12_27 WBL[27] WWL[12] SN_12_27 GND sg13_hv_nmos W=0.15u L=0.45u
MMS_12_27 MID_12_27 SN_12_27 GND GND sg13_lv_nmos W=0.3u L=0.13u
MMR_12_27 RBL[27] RWL[12] MID_12_27 GND sg13_lv_nmos W=0.3u L=0.13u
MMW_12_28 WBL[28] WWL[12] SN_12_28 GND sg13_hv_nmos W=0.15u L=0.45u
MMS_12_28 MID_12_28 SN_12_28 GND GND sg13_lv_nmos W=0.3u L=0.13u
MMR_12_28 RBL[28] RWL[12] MID_12_28 GND sg13_lv_nmos W=0.3u L=0.13u
MMW_12_29 WBL[29] WWL[12] SN_12_29 GND sg13_hv_nmos W=0.15u L=0.45u
MMS_12_29 MID_12_29 SN_12_29 GND GND sg13_lv_nmos W=0.3u L=0.13u
MMR_12_29 RBL[29] RWL[12] MID_12_29 GND sg13_lv_nmos W=0.3u L=0.13u
MMW_12_30 WBL[30] WWL[12] SN_12_30 GND sg13_hv_nmos W=0.15u L=0.45u
MMS_12_30 MID_12_30 SN_12_30 GND GND sg13_lv_nmos W=0.3u L=0.13u
MMR_12_30 RBL[30] RWL[12] MID_12_30 GND sg13_lv_nmos W=0.3u L=0.13u
MMW_12_31 WBL[31] WWL[12] SN_12_31 GND sg13_hv_nmos W=0.15u L=0.45u
MMS_12_31 MID_12_31 SN_12_31 GND GND sg13_lv_nmos W=0.3u L=0.13u
MMR_12_31 RBL[31] RWL[12] MID_12_31 GND sg13_lv_nmos W=0.3u L=0.13u
MMW_12_32 WBL[32] WWL[12] SN_12_32 GND sg13_hv_nmos W=0.15u L=0.45u
MMS_12_32 MID_12_32 SN_12_32 GND GND sg13_lv_nmos W=0.3u L=0.13u
MMR_12_32 RBL[32] RWL[12] MID_12_32 GND sg13_lv_nmos W=0.3u L=0.13u
MMW_12_33 WBL[33] WWL[12] SN_12_33 GND sg13_hv_nmos W=0.15u L=0.45u
MMS_12_33 MID_12_33 SN_12_33 GND GND sg13_lv_nmos W=0.3u L=0.13u
MMR_12_33 RBL[33] RWL[12] MID_12_33 GND sg13_lv_nmos W=0.3u L=0.13u
MMW_12_34 WBL[34] WWL[12] SN_12_34 GND sg13_hv_nmos W=0.15u L=0.45u
MMS_12_34 MID_12_34 SN_12_34 GND GND sg13_lv_nmos W=0.3u L=0.13u
MMR_12_34 RBL[34] RWL[12] MID_12_34 GND sg13_lv_nmos W=0.3u L=0.13u
MMW_12_35 WBL[35] WWL[12] SN_12_35 GND sg13_hv_nmos W=0.15u L=0.45u
MMS_12_35 MID_12_35 SN_12_35 GND GND sg13_lv_nmos W=0.3u L=0.13u
MMR_12_35 RBL[35] RWL[12] MID_12_35 GND sg13_lv_nmos W=0.3u L=0.13u
MMW_12_36 WBL[36] WWL[12] SN_12_36 GND sg13_hv_nmos W=0.15u L=0.45u
MMS_12_36 MID_12_36 SN_12_36 GND GND sg13_lv_nmos W=0.3u L=0.13u
MMR_12_36 RBL[36] RWL[12] MID_12_36 GND sg13_lv_nmos W=0.3u L=0.13u
MMW_12_37 WBL[37] WWL[12] SN_12_37 GND sg13_hv_nmos W=0.15u L=0.45u
MMS_12_37 MID_12_37 SN_12_37 GND GND sg13_lv_nmos W=0.3u L=0.13u
MMR_12_37 RBL[37] RWL[12] MID_12_37 GND sg13_lv_nmos W=0.3u L=0.13u
MMW_13_0 WBL[0] WWL[13] SN_13_0 GND sg13_hv_nmos W=0.15u L=0.45u
MMS_13_0 MID_13_0 SN_13_0 GND GND sg13_lv_nmos W=0.3u L=0.13u
MMR_13_0 RBL[0] RWL[13] MID_13_0 GND sg13_lv_nmos W=0.3u L=0.13u
MMW_13_1 WBL[1] WWL[13] SN_13_1 GND sg13_hv_nmos W=0.15u L=0.45u
MMS_13_1 MID_13_1 SN_13_1 GND GND sg13_lv_nmos W=0.3u L=0.13u
MMR_13_1 RBL[1] RWL[13] MID_13_1 GND sg13_lv_nmos W=0.3u L=0.13u
MMW_13_2 WBL[2] WWL[13] SN_13_2 GND sg13_hv_nmos W=0.15u L=0.45u
MMS_13_2 MID_13_2 SN_13_2 GND GND sg13_lv_nmos W=0.3u L=0.13u
MMR_13_2 RBL[2] RWL[13] MID_13_2 GND sg13_lv_nmos W=0.3u L=0.13u
MMW_13_3 WBL[3] WWL[13] SN_13_3 GND sg13_hv_nmos W=0.15u L=0.45u
MMS_13_3 MID_13_3 SN_13_3 GND GND sg13_lv_nmos W=0.3u L=0.13u
MMR_13_3 RBL[3] RWL[13] MID_13_3 GND sg13_lv_nmos W=0.3u L=0.13u
MMW_13_4 WBL[4] WWL[13] SN_13_4 GND sg13_hv_nmos W=0.15u L=0.45u
MMS_13_4 MID_13_4 SN_13_4 GND GND sg13_lv_nmos W=0.3u L=0.13u
MMR_13_4 RBL[4] RWL[13] MID_13_4 GND sg13_lv_nmos W=0.3u L=0.13u
MMW_13_5 WBL[5] WWL[13] SN_13_5 GND sg13_hv_nmos W=0.15u L=0.45u
MMS_13_5 MID_13_5 SN_13_5 GND GND sg13_lv_nmos W=0.3u L=0.13u
MMR_13_5 RBL[5] RWL[13] MID_13_5 GND sg13_lv_nmos W=0.3u L=0.13u
MMW_13_6 WBL[6] WWL[13] SN_13_6 GND sg13_hv_nmos W=0.15u L=0.45u
MMS_13_6 MID_13_6 SN_13_6 GND GND sg13_lv_nmos W=0.3u L=0.13u
MMR_13_6 RBL[6] RWL[13] MID_13_6 GND sg13_lv_nmos W=0.3u L=0.13u
MMW_13_7 WBL[7] WWL[13] SN_13_7 GND sg13_hv_nmos W=0.15u L=0.45u
MMS_13_7 MID_13_7 SN_13_7 GND GND sg13_lv_nmos W=0.3u L=0.13u
MMR_13_7 RBL[7] RWL[13] MID_13_7 GND sg13_lv_nmos W=0.3u L=0.13u
MMW_13_8 WBL[8] WWL[13] SN_13_8 GND sg13_hv_nmos W=0.15u L=0.45u
MMS_13_8 MID_13_8 SN_13_8 GND GND sg13_lv_nmos W=0.3u L=0.13u
MMR_13_8 RBL[8] RWL[13] MID_13_8 GND sg13_lv_nmos W=0.3u L=0.13u
MMW_13_9 WBL[9] WWL[13] SN_13_9 GND sg13_hv_nmos W=0.15u L=0.45u
MMS_13_9 MID_13_9 SN_13_9 GND GND sg13_lv_nmos W=0.3u L=0.13u
MMR_13_9 RBL[9] RWL[13] MID_13_9 GND sg13_lv_nmos W=0.3u L=0.13u
MMW_13_10 WBL[10] WWL[13] SN_13_10 GND sg13_hv_nmos W=0.15u L=0.45u
MMS_13_10 MID_13_10 SN_13_10 GND GND sg13_lv_nmos W=0.3u L=0.13u
MMR_13_10 RBL[10] RWL[13] MID_13_10 GND sg13_lv_nmos W=0.3u L=0.13u
MMW_13_11 WBL[11] WWL[13] SN_13_11 GND sg13_hv_nmos W=0.15u L=0.45u
MMS_13_11 MID_13_11 SN_13_11 GND GND sg13_lv_nmos W=0.3u L=0.13u
MMR_13_11 RBL[11] RWL[13] MID_13_11 GND sg13_lv_nmos W=0.3u L=0.13u
MMW_13_12 WBL[12] WWL[13] SN_13_12 GND sg13_hv_nmos W=0.15u L=0.45u
MMS_13_12 MID_13_12 SN_13_12 GND GND sg13_lv_nmos W=0.3u L=0.13u
MMR_13_12 RBL[12] RWL[13] MID_13_12 GND sg13_lv_nmos W=0.3u L=0.13u
MMW_13_13 WBL[13] WWL[13] SN_13_13 GND sg13_hv_nmos W=0.15u L=0.45u
MMS_13_13 MID_13_13 SN_13_13 GND GND sg13_lv_nmos W=0.3u L=0.13u
MMR_13_13 RBL[13] RWL[13] MID_13_13 GND sg13_lv_nmos W=0.3u L=0.13u
MMW_13_14 WBL[14] WWL[13] SN_13_14 GND sg13_hv_nmos W=0.15u L=0.45u
MMS_13_14 MID_13_14 SN_13_14 GND GND sg13_lv_nmos W=0.3u L=0.13u
MMR_13_14 RBL[14] RWL[13] MID_13_14 GND sg13_lv_nmos W=0.3u L=0.13u
MMW_13_15 WBL[15] WWL[13] SN_13_15 GND sg13_hv_nmos W=0.15u L=0.45u
MMS_13_15 MID_13_15 SN_13_15 GND GND sg13_lv_nmos W=0.3u L=0.13u
MMR_13_15 RBL[15] RWL[13] MID_13_15 GND sg13_lv_nmos W=0.3u L=0.13u
MMW_13_16 WBL[16] WWL[13] SN_13_16 GND sg13_hv_nmos W=0.15u L=0.45u
MMS_13_16 MID_13_16 SN_13_16 GND GND sg13_lv_nmos W=0.3u L=0.13u
MMR_13_16 RBL[16] RWL[13] MID_13_16 GND sg13_lv_nmos W=0.3u L=0.13u
MMW_13_17 WBL[17] WWL[13] SN_13_17 GND sg13_hv_nmos W=0.15u L=0.45u
MMS_13_17 MID_13_17 SN_13_17 GND GND sg13_lv_nmos W=0.3u L=0.13u
MMR_13_17 RBL[17] RWL[13] MID_13_17 GND sg13_lv_nmos W=0.3u L=0.13u
MMW_13_18 WBL[18] WWL[13] SN_13_18 GND sg13_hv_nmos W=0.15u L=0.45u
MMS_13_18 MID_13_18 SN_13_18 GND GND sg13_lv_nmos W=0.3u L=0.13u
MMR_13_18 RBL[18] RWL[13] MID_13_18 GND sg13_lv_nmos W=0.3u L=0.13u
MMW_13_19 WBL[19] WWL[13] SN_13_19 GND sg13_hv_nmos W=0.15u L=0.45u
MMS_13_19 MID_13_19 SN_13_19 GND GND sg13_lv_nmos W=0.3u L=0.13u
MMR_13_19 RBL[19] RWL[13] MID_13_19 GND sg13_lv_nmos W=0.3u L=0.13u
MMW_13_20 WBL[20] WWL[13] SN_13_20 GND sg13_hv_nmos W=0.15u L=0.45u
MMS_13_20 MID_13_20 SN_13_20 GND GND sg13_lv_nmos W=0.3u L=0.13u
MMR_13_20 RBL[20] RWL[13] MID_13_20 GND sg13_lv_nmos W=0.3u L=0.13u
MMW_13_21 WBL[21] WWL[13] SN_13_21 GND sg13_hv_nmos W=0.15u L=0.45u
MMS_13_21 MID_13_21 SN_13_21 GND GND sg13_lv_nmos W=0.3u L=0.13u
MMR_13_21 RBL[21] RWL[13] MID_13_21 GND sg13_lv_nmos W=0.3u L=0.13u
MMW_13_22 WBL[22] WWL[13] SN_13_22 GND sg13_hv_nmos W=0.15u L=0.45u
MMS_13_22 MID_13_22 SN_13_22 GND GND sg13_lv_nmos W=0.3u L=0.13u
MMR_13_22 RBL[22] RWL[13] MID_13_22 GND sg13_lv_nmos W=0.3u L=0.13u
MMW_13_23 WBL[23] WWL[13] SN_13_23 GND sg13_hv_nmos W=0.15u L=0.45u
MMS_13_23 MID_13_23 SN_13_23 GND GND sg13_lv_nmos W=0.3u L=0.13u
MMR_13_23 RBL[23] RWL[13] MID_13_23 GND sg13_lv_nmos W=0.3u L=0.13u
MMW_13_24 WBL[24] WWL[13] SN_13_24 GND sg13_hv_nmos W=0.15u L=0.45u
MMS_13_24 MID_13_24 SN_13_24 GND GND sg13_lv_nmos W=0.3u L=0.13u
MMR_13_24 RBL[24] RWL[13] MID_13_24 GND sg13_lv_nmos W=0.3u L=0.13u
MMW_13_25 WBL[25] WWL[13] SN_13_25 GND sg13_hv_nmos W=0.15u L=0.45u
MMS_13_25 MID_13_25 SN_13_25 GND GND sg13_lv_nmos W=0.3u L=0.13u
MMR_13_25 RBL[25] RWL[13] MID_13_25 GND sg13_lv_nmos W=0.3u L=0.13u
MMW_13_26 WBL[26] WWL[13] SN_13_26 GND sg13_hv_nmos W=0.15u L=0.45u
MMS_13_26 MID_13_26 SN_13_26 GND GND sg13_lv_nmos W=0.3u L=0.13u
MMR_13_26 RBL[26] RWL[13] MID_13_26 GND sg13_lv_nmos W=0.3u L=0.13u
MMW_13_27 WBL[27] WWL[13] SN_13_27 GND sg13_hv_nmos W=0.15u L=0.45u
MMS_13_27 MID_13_27 SN_13_27 GND GND sg13_lv_nmos W=0.3u L=0.13u
MMR_13_27 RBL[27] RWL[13] MID_13_27 GND sg13_lv_nmos W=0.3u L=0.13u
MMW_13_28 WBL[28] WWL[13] SN_13_28 GND sg13_hv_nmos W=0.15u L=0.45u
MMS_13_28 MID_13_28 SN_13_28 GND GND sg13_lv_nmos W=0.3u L=0.13u
MMR_13_28 RBL[28] RWL[13] MID_13_28 GND sg13_lv_nmos W=0.3u L=0.13u
MMW_13_29 WBL[29] WWL[13] SN_13_29 GND sg13_hv_nmos W=0.15u L=0.45u
MMS_13_29 MID_13_29 SN_13_29 GND GND sg13_lv_nmos W=0.3u L=0.13u
MMR_13_29 RBL[29] RWL[13] MID_13_29 GND sg13_lv_nmos W=0.3u L=0.13u
MMW_13_30 WBL[30] WWL[13] SN_13_30 GND sg13_hv_nmos W=0.15u L=0.45u
MMS_13_30 MID_13_30 SN_13_30 GND GND sg13_lv_nmos W=0.3u L=0.13u
MMR_13_30 RBL[30] RWL[13] MID_13_30 GND sg13_lv_nmos W=0.3u L=0.13u
MMW_13_31 WBL[31] WWL[13] SN_13_31 GND sg13_hv_nmos W=0.15u L=0.45u
MMS_13_31 MID_13_31 SN_13_31 GND GND sg13_lv_nmos W=0.3u L=0.13u
MMR_13_31 RBL[31] RWL[13] MID_13_31 GND sg13_lv_nmos W=0.3u L=0.13u
MMW_13_32 WBL[32] WWL[13] SN_13_32 GND sg13_hv_nmos W=0.15u L=0.45u
MMS_13_32 MID_13_32 SN_13_32 GND GND sg13_lv_nmos W=0.3u L=0.13u
MMR_13_32 RBL[32] RWL[13] MID_13_32 GND sg13_lv_nmos W=0.3u L=0.13u
MMW_13_33 WBL[33] WWL[13] SN_13_33 GND sg13_hv_nmos W=0.15u L=0.45u
MMS_13_33 MID_13_33 SN_13_33 GND GND sg13_lv_nmos W=0.3u L=0.13u
MMR_13_33 RBL[33] RWL[13] MID_13_33 GND sg13_lv_nmos W=0.3u L=0.13u
MMW_13_34 WBL[34] WWL[13] SN_13_34 GND sg13_hv_nmos W=0.15u L=0.45u
MMS_13_34 MID_13_34 SN_13_34 GND GND sg13_lv_nmos W=0.3u L=0.13u
MMR_13_34 RBL[34] RWL[13] MID_13_34 GND sg13_lv_nmos W=0.3u L=0.13u
MMW_13_35 WBL[35] WWL[13] SN_13_35 GND sg13_hv_nmos W=0.15u L=0.45u
MMS_13_35 MID_13_35 SN_13_35 GND GND sg13_lv_nmos W=0.3u L=0.13u
MMR_13_35 RBL[35] RWL[13] MID_13_35 GND sg13_lv_nmos W=0.3u L=0.13u
MMW_13_36 WBL[36] WWL[13] SN_13_36 GND sg13_hv_nmos W=0.15u L=0.45u
MMS_13_36 MID_13_36 SN_13_36 GND GND sg13_lv_nmos W=0.3u L=0.13u
MMR_13_36 RBL[36] RWL[13] MID_13_36 GND sg13_lv_nmos W=0.3u L=0.13u
MMW_13_37 WBL[37] WWL[13] SN_13_37 GND sg13_hv_nmos W=0.15u L=0.45u
MMS_13_37 MID_13_37 SN_13_37 GND GND sg13_lv_nmos W=0.3u L=0.13u
MMR_13_37 RBL[37] RWL[13] MID_13_37 GND sg13_lv_nmos W=0.3u L=0.13u
MMW_14_0 WBL[0] WWL[14] SN_14_0 GND sg13_hv_nmos W=0.15u L=0.45u
MMS_14_0 MID_14_0 SN_14_0 GND GND sg13_lv_nmos W=0.3u L=0.13u
MMR_14_0 RBL[0] RWL[14] MID_14_0 GND sg13_lv_nmos W=0.3u L=0.13u
MMW_14_1 WBL[1] WWL[14] SN_14_1 GND sg13_hv_nmos W=0.15u L=0.45u
MMS_14_1 MID_14_1 SN_14_1 GND GND sg13_lv_nmos W=0.3u L=0.13u
MMR_14_1 RBL[1] RWL[14] MID_14_1 GND sg13_lv_nmos W=0.3u L=0.13u
MMW_14_2 WBL[2] WWL[14] SN_14_2 GND sg13_hv_nmos W=0.15u L=0.45u
MMS_14_2 MID_14_2 SN_14_2 GND GND sg13_lv_nmos W=0.3u L=0.13u
MMR_14_2 RBL[2] RWL[14] MID_14_2 GND sg13_lv_nmos W=0.3u L=0.13u
MMW_14_3 WBL[3] WWL[14] SN_14_3 GND sg13_hv_nmos W=0.15u L=0.45u
MMS_14_3 MID_14_3 SN_14_3 GND GND sg13_lv_nmos W=0.3u L=0.13u
MMR_14_3 RBL[3] RWL[14] MID_14_3 GND sg13_lv_nmos W=0.3u L=0.13u
MMW_14_4 WBL[4] WWL[14] SN_14_4 GND sg13_hv_nmos W=0.15u L=0.45u
MMS_14_4 MID_14_4 SN_14_4 GND GND sg13_lv_nmos W=0.3u L=0.13u
MMR_14_4 RBL[4] RWL[14] MID_14_4 GND sg13_lv_nmos W=0.3u L=0.13u
MMW_14_5 WBL[5] WWL[14] SN_14_5 GND sg13_hv_nmos W=0.15u L=0.45u
MMS_14_5 MID_14_5 SN_14_5 GND GND sg13_lv_nmos W=0.3u L=0.13u
MMR_14_5 RBL[5] RWL[14] MID_14_5 GND sg13_lv_nmos W=0.3u L=0.13u
MMW_14_6 WBL[6] WWL[14] SN_14_6 GND sg13_hv_nmos W=0.15u L=0.45u
MMS_14_6 MID_14_6 SN_14_6 GND GND sg13_lv_nmos W=0.3u L=0.13u
MMR_14_6 RBL[6] RWL[14] MID_14_6 GND sg13_lv_nmos W=0.3u L=0.13u
MMW_14_7 WBL[7] WWL[14] SN_14_7 GND sg13_hv_nmos W=0.15u L=0.45u
MMS_14_7 MID_14_7 SN_14_7 GND GND sg13_lv_nmos W=0.3u L=0.13u
MMR_14_7 RBL[7] RWL[14] MID_14_7 GND sg13_lv_nmos W=0.3u L=0.13u
MMW_14_8 WBL[8] WWL[14] SN_14_8 GND sg13_hv_nmos W=0.15u L=0.45u
MMS_14_8 MID_14_8 SN_14_8 GND GND sg13_lv_nmos W=0.3u L=0.13u
MMR_14_8 RBL[8] RWL[14] MID_14_8 GND sg13_lv_nmos W=0.3u L=0.13u
MMW_14_9 WBL[9] WWL[14] SN_14_9 GND sg13_hv_nmos W=0.15u L=0.45u
MMS_14_9 MID_14_9 SN_14_9 GND GND sg13_lv_nmos W=0.3u L=0.13u
MMR_14_9 RBL[9] RWL[14] MID_14_9 GND sg13_lv_nmos W=0.3u L=0.13u
MMW_14_10 WBL[10] WWL[14] SN_14_10 GND sg13_hv_nmos W=0.15u L=0.45u
MMS_14_10 MID_14_10 SN_14_10 GND GND sg13_lv_nmos W=0.3u L=0.13u
MMR_14_10 RBL[10] RWL[14] MID_14_10 GND sg13_lv_nmos W=0.3u L=0.13u
MMW_14_11 WBL[11] WWL[14] SN_14_11 GND sg13_hv_nmos W=0.15u L=0.45u
MMS_14_11 MID_14_11 SN_14_11 GND GND sg13_lv_nmos W=0.3u L=0.13u
MMR_14_11 RBL[11] RWL[14] MID_14_11 GND sg13_lv_nmos W=0.3u L=0.13u
MMW_14_12 WBL[12] WWL[14] SN_14_12 GND sg13_hv_nmos W=0.15u L=0.45u
MMS_14_12 MID_14_12 SN_14_12 GND GND sg13_lv_nmos W=0.3u L=0.13u
MMR_14_12 RBL[12] RWL[14] MID_14_12 GND sg13_lv_nmos W=0.3u L=0.13u
MMW_14_13 WBL[13] WWL[14] SN_14_13 GND sg13_hv_nmos W=0.15u L=0.45u
MMS_14_13 MID_14_13 SN_14_13 GND GND sg13_lv_nmos W=0.3u L=0.13u
MMR_14_13 RBL[13] RWL[14] MID_14_13 GND sg13_lv_nmos W=0.3u L=0.13u
MMW_14_14 WBL[14] WWL[14] SN_14_14 GND sg13_hv_nmos W=0.15u L=0.45u
MMS_14_14 MID_14_14 SN_14_14 GND GND sg13_lv_nmos W=0.3u L=0.13u
MMR_14_14 RBL[14] RWL[14] MID_14_14 GND sg13_lv_nmos W=0.3u L=0.13u
MMW_14_15 WBL[15] WWL[14] SN_14_15 GND sg13_hv_nmos W=0.15u L=0.45u
MMS_14_15 MID_14_15 SN_14_15 GND GND sg13_lv_nmos W=0.3u L=0.13u
MMR_14_15 RBL[15] RWL[14] MID_14_15 GND sg13_lv_nmos W=0.3u L=0.13u
MMW_14_16 WBL[16] WWL[14] SN_14_16 GND sg13_hv_nmos W=0.15u L=0.45u
MMS_14_16 MID_14_16 SN_14_16 GND GND sg13_lv_nmos W=0.3u L=0.13u
MMR_14_16 RBL[16] RWL[14] MID_14_16 GND sg13_lv_nmos W=0.3u L=0.13u
MMW_14_17 WBL[17] WWL[14] SN_14_17 GND sg13_hv_nmos W=0.15u L=0.45u
MMS_14_17 MID_14_17 SN_14_17 GND GND sg13_lv_nmos W=0.3u L=0.13u
MMR_14_17 RBL[17] RWL[14] MID_14_17 GND sg13_lv_nmos W=0.3u L=0.13u
MMW_14_18 WBL[18] WWL[14] SN_14_18 GND sg13_hv_nmos W=0.15u L=0.45u
MMS_14_18 MID_14_18 SN_14_18 GND GND sg13_lv_nmos W=0.3u L=0.13u
MMR_14_18 RBL[18] RWL[14] MID_14_18 GND sg13_lv_nmos W=0.3u L=0.13u
MMW_14_19 WBL[19] WWL[14] SN_14_19 GND sg13_hv_nmos W=0.15u L=0.45u
MMS_14_19 MID_14_19 SN_14_19 GND GND sg13_lv_nmos W=0.3u L=0.13u
MMR_14_19 RBL[19] RWL[14] MID_14_19 GND sg13_lv_nmos W=0.3u L=0.13u
MMW_14_20 WBL[20] WWL[14] SN_14_20 GND sg13_hv_nmos W=0.15u L=0.45u
MMS_14_20 MID_14_20 SN_14_20 GND GND sg13_lv_nmos W=0.3u L=0.13u
MMR_14_20 RBL[20] RWL[14] MID_14_20 GND sg13_lv_nmos W=0.3u L=0.13u
MMW_14_21 WBL[21] WWL[14] SN_14_21 GND sg13_hv_nmos W=0.15u L=0.45u
MMS_14_21 MID_14_21 SN_14_21 GND GND sg13_lv_nmos W=0.3u L=0.13u
MMR_14_21 RBL[21] RWL[14] MID_14_21 GND sg13_lv_nmos W=0.3u L=0.13u
MMW_14_22 WBL[22] WWL[14] SN_14_22 GND sg13_hv_nmos W=0.15u L=0.45u
MMS_14_22 MID_14_22 SN_14_22 GND GND sg13_lv_nmos W=0.3u L=0.13u
MMR_14_22 RBL[22] RWL[14] MID_14_22 GND sg13_lv_nmos W=0.3u L=0.13u
MMW_14_23 WBL[23] WWL[14] SN_14_23 GND sg13_hv_nmos W=0.15u L=0.45u
MMS_14_23 MID_14_23 SN_14_23 GND GND sg13_lv_nmos W=0.3u L=0.13u
MMR_14_23 RBL[23] RWL[14] MID_14_23 GND sg13_lv_nmos W=0.3u L=0.13u
MMW_14_24 WBL[24] WWL[14] SN_14_24 GND sg13_hv_nmos W=0.15u L=0.45u
MMS_14_24 MID_14_24 SN_14_24 GND GND sg13_lv_nmos W=0.3u L=0.13u
MMR_14_24 RBL[24] RWL[14] MID_14_24 GND sg13_lv_nmos W=0.3u L=0.13u
MMW_14_25 WBL[25] WWL[14] SN_14_25 GND sg13_hv_nmos W=0.15u L=0.45u
MMS_14_25 MID_14_25 SN_14_25 GND GND sg13_lv_nmos W=0.3u L=0.13u
MMR_14_25 RBL[25] RWL[14] MID_14_25 GND sg13_lv_nmos W=0.3u L=0.13u
MMW_14_26 WBL[26] WWL[14] SN_14_26 GND sg13_hv_nmos W=0.15u L=0.45u
MMS_14_26 MID_14_26 SN_14_26 GND GND sg13_lv_nmos W=0.3u L=0.13u
MMR_14_26 RBL[26] RWL[14] MID_14_26 GND sg13_lv_nmos W=0.3u L=0.13u
MMW_14_27 WBL[27] WWL[14] SN_14_27 GND sg13_hv_nmos W=0.15u L=0.45u
MMS_14_27 MID_14_27 SN_14_27 GND GND sg13_lv_nmos W=0.3u L=0.13u
MMR_14_27 RBL[27] RWL[14] MID_14_27 GND sg13_lv_nmos W=0.3u L=0.13u
MMW_14_28 WBL[28] WWL[14] SN_14_28 GND sg13_hv_nmos W=0.15u L=0.45u
MMS_14_28 MID_14_28 SN_14_28 GND GND sg13_lv_nmos W=0.3u L=0.13u
MMR_14_28 RBL[28] RWL[14] MID_14_28 GND sg13_lv_nmos W=0.3u L=0.13u
MMW_14_29 WBL[29] WWL[14] SN_14_29 GND sg13_hv_nmos W=0.15u L=0.45u
MMS_14_29 MID_14_29 SN_14_29 GND GND sg13_lv_nmos W=0.3u L=0.13u
MMR_14_29 RBL[29] RWL[14] MID_14_29 GND sg13_lv_nmos W=0.3u L=0.13u
MMW_14_30 WBL[30] WWL[14] SN_14_30 GND sg13_hv_nmos W=0.15u L=0.45u
MMS_14_30 MID_14_30 SN_14_30 GND GND sg13_lv_nmos W=0.3u L=0.13u
MMR_14_30 RBL[30] RWL[14] MID_14_30 GND sg13_lv_nmos W=0.3u L=0.13u
MMW_14_31 WBL[31] WWL[14] SN_14_31 GND sg13_hv_nmos W=0.15u L=0.45u
MMS_14_31 MID_14_31 SN_14_31 GND GND sg13_lv_nmos W=0.3u L=0.13u
MMR_14_31 RBL[31] RWL[14] MID_14_31 GND sg13_lv_nmos W=0.3u L=0.13u
MMW_14_32 WBL[32] WWL[14] SN_14_32 GND sg13_hv_nmos W=0.15u L=0.45u
MMS_14_32 MID_14_32 SN_14_32 GND GND sg13_lv_nmos W=0.3u L=0.13u
MMR_14_32 RBL[32] RWL[14] MID_14_32 GND sg13_lv_nmos W=0.3u L=0.13u
MMW_14_33 WBL[33] WWL[14] SN_14_33 GND sg13_hv_nmos W=0.15u L=0.45u
MMS_14_33 MID_14_33 SN_14_33 GND GND sg13_lv_nmos W=0.3u L=0.13u
MMR_14_33 RBL[33] RWL[14] MID_14_33 GND sg13_lv_nmos W=0.3u L=0.13u
MMW_14_34 WBL[34] WWL[14] SN_14_34 GND sg13_hv_nmos W=0.15u L=0.45u
MMS_14_34 MID_14_34 SN_14_34 GND GND sg13_lv_nmos W=0.3u L=0.13u
MMR_14_34 RBL[34] RWL[14] MID_14_34 GND sg13_lv_nmos W=0.3u L=0.13u
MMW_14_35 WBL[35] WWL[14] SN_14_35 GND sg13_hv_nmos W=0.15u L=0.45u
MMS_14_35 MID_14_35 SN_14_35 GND GND sg13_lv_nmos W=0.3u L=0.13u
MMR_14_35 RBL[35] RWL[14] MID_14_35 GND sg13_lv_nmos W=0.3u L=0.13u
MMW_14_36 WBL[36] WWL[14] SN_14_36 GND sg13_hv_nmos W=0.15u L=0.45u
MMS_14_36 MID_14_36 SN_14_36 GND GND sg13_lv_nmos W=0.3u L=0.13u
MMR_14_36 RBL[36] RWL[14] MID_14_36 GND sg13_lv_nmos W=0.3u L=0.13u
MMW_14_37 WBL[37] WWL[14] SN_14_37 GND sg13_hv_nmos W=0.15u L=0.45u
MMS_14_37 MID_14_37 SN_14_37 GND GND sg13_lv_nmos W=0.3u L=0.13u
MMR_14_37 RBL[37] RWL[14] MID_14_37 GND sg13_lv_nmos W=0.3u L=0.13u
MMW_15_0 WBL[0] WWL[15] SN_15_0 GND sg13_hv_nmos W=0.15u L=0.45u
MMS_15_0 MID_15_0 SN_15_0 GND GND sg13_lv_nmos W=0.3u L=0.13u
MMR_15_0 RBL[0] RWL[15] MID_15_0 GND sg13_lv_nmos W=0.3u L=0.13u
MMW_15_1 WBL[1] WWL[15] SN_15_1 GND sg13_hv_nmos W=0.15u L=0.45u
MMS_15_1 MID_15_1 SN_15_1 GND GND sg13_lv_nmos W=0.3u L=0.13u
MMR_15_1 RBL[1] RWL[15] MID_15_1 GND sg13_lv_nmos W=0.3u L=0.13u
MMW_15_2 WBL[2] WWL[15] SN_15_2 GND sg13_hv_nmos W=0.15u L=0.45u
MMS_15_2 MID_15_2 SN_15_2 GND GND sg13_lv_nmos W=0.3u L=0.13u
MMR_15_2 RBL[2] RWL[15] MID_15_2 GND sg13_lv_nmos W=0.3u L=0.13u
MMW_15_3 WBL[3] WWL[15] SN_15_3 GND sg13_hv_nmos W=0.15u L=0.45u
MMS_15_3 MID_15_3 SN_15_3 GND GND sg13_lv_nmos W=0.3u L=0.13u
MMR_15_3 RBL[3] RWL[15] MID_15_3 GND sg13_lv_nmos W=0.3u L=0.13u
MMW_15_4 WBL[4] WWL[15] SN_15_4 GND sg13_hv_nmos W=0.15u L=0.45u
MMS_15_4 MID_15_4 SN_15_4 GND GND sg13_lv_nmos W=0.3u L=0.13u
MMR_15_4 RBL[4] RWL[15] MID_15_4 GND sg13_lv_nmos W=0.3u L=0.13u
MMW_15_5 WBL[5] WWL[15] SN_15_5 GND sg13_hv_nmos W=0.15u L=0.45u
MMS_15_5 MID_15_5 SN_15_5 GND GND sg13_lv_nmos W=0.3u L=0.13u
MMR_15_5 RBL[5] RWL[15] MID_15_5 GND sg13_lv_nmos W=0.3u L=0.13u
MMW_15_6 WBL[6] WWL[15] SN_15_6 GND sg13_hv_nmos W=0.15u L=0.45u
MMS_15_6 MID_15_6 SN_15_6 GND GND sg13_lv_nmos W=0.3u L=0.13u
MMR_15_6 RBL[6] RWL[15] MID_15_6 GND sg13_lv_nmos W=0.3u L=0.13u
MMW_15_7 WBL[7] WWL[15] SN_15_7 GND sg13_hv_nmos W=0.15u L=0.45u
MMS_15_7 MID_15_7 SN_15_7 GND GND sg13_lv_nmos W=0.3u L=0.13u
MMR_15_7 RBL[7] RWL[15] MID_15_7 GND sg13_lv_nmos W=0.3u L=0.13u
MMW_15_8 WBL[8] WWL[15] SN_15_8 GND sg13_hv_nmos W=0.15u L=0.45u
MMS_15_8 MID_15_8 SN_15_8 GND GND sg13_lv_nmos W=0.3u L=0.13u
MMR_15_8 RBL[8] RWL[15] MID_15_8 GND sg13_lv_nmos W=0.3u L=0.13u
MMW_15_9 WBL[9] WWL[15] SN_15_9 GND sg13_hv_nmos W=0.15u L=0.45u
MMS_15_9 MID_15_9 SN_15_9 GND GND sg13_lv_nmos W=0.3u L=0.13u
MMR_15_9 RBL[9] RWL[15] MID_15_9 GND sg13_lv_nmos W=0.3u L=0.13u
MMW_15_10 WBL[10] WWL[15] SN_15_10 GND sg13_hv_nmos W=0.15u L=0.45u
MMS_15_10 MID_15_10 SN_15_10 GND GND sg13_lv_nmos W=0.3u L=0.13u
MMR_15_10 RBL[10] RWL[15] MID_15_10 GND sg13_lv_nmos W=0.3u L=0.13u
MMW_15_11 WBL[11] WWL[15] SN_15_11 GND sg13_hv_nmos W=0.15u L=0.45u
MMS_15_11 MID_15_11 SN_15_11 GND GND sg13_lv_nmos W=0.3u L=0.13u
MMR_15_11 RBL[11] RWL[15] MID_15_11 GND sg13_lv_nmos W=0.3u L=0.13u
MMW_15_12 WBL[12] WWL[15] SN_15_12 GND sg13_hv_nmos W=0.15u L=0.45u
MMS_15_12 MID_15_12 SN_15_12 GND GND sg13_lv_nmos W=0.3u L=0.13u
MMR_15_12 RBL[12] RWL[15] MID_15_12 GND sg13_lv_nmos W=0.3u L=0.13u
MMW_15_13 WBL[13] WWL[15] SN_15_13 GND sg13_hv_nmos W=0.15u L=0.45u
MMS_15_13 MID_15_13 SN_15_13 GND GND sg13_lv_nmos W=0.3u L=0.13u
MMR_15_13 RBL[13] RWL[15] MID_15_13 GND sg13_lv_nmos W=0.3u L=0.13u
MMW_15_14 WBL[14] WWL[15] SN_15_14 GND sg13_hv_nmos W=0.15u L=0.45u
MMS_15_14 MID_15_14 SN_15_14 GND GND sg13_lv_nmos W=0.3u L=0.13u
MMR_15_14 RBL[14] RWL[15] MID_15_14 GND sg13_lv_nmos W=0.3u L=0.13u
MMW_15_15 WBL[15] WWL[15] SN_15_15 GND sg13_hv_nmos W=0.15u L=0.45u
MMS_15_15 MID_15_15 SN_15_15 GND GND sg13_lv_nmos W=0.3u L=0.13u
MMR_15_15 RBL[15] RWL[15] MID_15_15 GND sg13_lv_nmos W=0.3u L=0.13u
MMW_15_16 WBL[16] WWL[15] SN_15_16 GND sg13_hv_nmos W=0.15u L=0.45u
MMS_15_16 MID_15_16 SN_15_16 GND GND sg13_lv_nmos W=0.3u L=0.13u
MMR_15_16 RBL[16] RWL[15] MID_15_16 GND sg13_lv_nmos W=0.3u L=0.13u
MMW_15_17 WBL[17] WWL[15] SN_15_17 GND sg13_hv_nmos W=0.15u L=0.45u
MMS_15_17 MID_15_17 SN_15_17 GND GND sg13_lv_nmos W=0.3u L=0.13u
MMR_15_17 RBL[17] RWL[15] MID_15_17 GND sg13_lv_nmos W=0.3u L=0.13u
MMW_15_18 WBL[18] WWL[15] SN_15_18 GND sg13_hv_nmos W=0.15u L=0.45u
MMS_15_18 MID_15_18 SN_15_18 GND GND sg13_lv_nmos W=0.3u L=0.13u
MMR_15_18 RBL[18] RWL[15] MID_15_18 GND sg13_lv_nmos W=0.3u L=0.13u
MMW_15_19 WBL[19] WWL[15] SN_15_19 GND sg13_hv_nmos W=0.15u L=0.45u
MMS_15_19 MID_15_19 SN_15_19 GND GND sg13_lv_nmos W=0.3u L=0.13u
MMR_15_19 RBL[19] RWL[15] MID_15_19 GND sg13_lv_nmos W=0.3u L=0.13u
MMW_15_20 WBL[20] WWL[15] SN_15_20 GND sg13_hv_nmos W=0.15u L=0.45u
MMS_15_20 MID_15_20 SN_15_20 GND GND sg13_lv_nmos W=0.3u L=0.13u
MMR_15_20 RBL[20] RWL[15] MID_15_20 GND sg13_lv_nmos W=0.3u L=0.13u
MMW_15_21 WBL[21] WWL[15] SN_15_21 GND sg13_hv_nmos W=0.15u L=0.45u
MMS_15_21 MID_15_21 SN_15_21 GND GND sg13_lv_nmos W=0.3u L=0.13u
MMR_15_21 RBL[21] RWL[15] MID_15_21 GND sg13_lv_nmos W=0.3u L=0.13u
MMW_15_22 WBL[22] WWL[15] SN_15_22 GND sg13_hv_nmos W=0.15u L=0.45u
MMS_15_22 MID_15_22 SN_15_22 GND GND sg13_lv_nmos W=0.3u L=0.13u
MMR_15_22 RBL[22] RWL[15] MID_15_22 GND sg13_lv_nmos W=0.3u L=0.13u
MMW_15_23 WBL[23] WWL[15] SN_15_23 GND sg13_hv_nmos W=0.15u L=0.45u
MMS_15_23 MID_15_23 SN_15_23 GND GND sg13_lv_nmos W=0.3u L=0.13u
MMR_15_23 RBL[23] RWL[15] MID_15_23 GND sg13_lv_nmos W=0.3u L=0.13u
MMW_15_24 WBL[24] WWL[15] SN_15_24 GND sg13_hv_nmos W=0.15u L=0.45u
MMS_15_24 MID_15_24 SN_15_24 GND GND sg13_lv_nmos W=0.3u L=0.13u
MMR_15_24 RBL[24] RWL[15] MID_15_24 GND sg13_lv_nmos W=0.3u L=0.13u
MMW_15_25 WBL[25] WWL[15] SN_15_25 GND sg13_hv_nmos W=0.15u L=0.45u
MMS_15_25 MID_15_25 SN_15_25 GND GND sg13_lv_nmos W=0.3u L=0.13u
MMR_15_25 RBL[25] RWL[15] MID_15_25 GND sg13_lv_nmos W=0.3u L=0.13u
MMW_15_26 WBL[26] WWL[15] SN_15_26 GND sg13_hv_nmos W=0.15u L=0.45u
MMS_15_26 MID_15_26 SN_15_26 GND GND sg13_lv_nmos W=0.3u L=0.13u
MMR_15_26 RBL[26] RWL[15] MID_15_26 GND sg13_lv_nmos W=0.3u L=0.13u
MMW_15_27 WBL[27] WWL[15] SN_15_27 GND sg13_hv_nmos W=0.15u L=0.45u
MMS_15_27 MID_15_27 SN_15_27 GND GND sg13_lv_nmos W=0.3u L=0.13u
MMR_15_27 RBL[27] RWL[15] MID_15_27 GND sg13_lv_nmos W=0.3u L=0.13u
MMW_15_28 WBL[28] WWL[15] SN_15_28 GND sg13_hv_nmos W=0.15u L=0.45u
MMS_15_28 MID_15_28 SN_15_28 GND GND sg13_lv_nmos W=0.3u L=0.13u
MMR_15_28 RBL[28] RWL[15] MID_15_28 GND sg13_lv_nmos W=0.3u L=0.13u
MMW_15_29 WBL[29] WWL[15] SN_15_29 GND sg13_hv_nmos W=0.15u L=0.45u
MMS_15_29 MID_15_29 SN_15_29 GND GND sg13_lv_nmos W=0.3u L=0.13u
MMR_15_29 RBL[29] RWL[15] MID_15_29 GND sg13_lv_nmos W=0.3u L=0.13u
MMW_15_30 WBL[30] WWL[15] SN_15_30 GND sg13_hv_nmos W=0.15u L=0.45u
MMS_15_30 MID_15_30 SN_15_30 GND GND sg13_lv_nmos W=0.3u L=0.13u
MMR_15_30 RBL[30] RWL[15] MID_15_30 GND sg13_lv_nmos W=0.3u L=0.13u
MMW_15_31 WBL[31] WWL[15] SN_15_31 GND sg13_hv_nmos W=0.15u L=0.45u
MMS_15_31 MID_15_31 SN_15_31 GND GND sg13_lv_nmos W=0.3u L=0.13u
MMR_15_31 RBL[31] RWL[15] MID_15_31 GND sg13_lv_nmos W=0.3u L=0.13u
MMW_15_32 WBL[32] WWL[15] SN_15_32 GND sg13_hv_nmos W=0.15u L=0.45u
MMS_15_32 MID_15_32 SN_15_32 GND GND sg13_lv_nmos W=0.3u L=0.13u
MMR_15_32 RBL[32] RWL[15] MID_15_32 GND sg13_lv_nmos W=0.3u L=0.13u
MMW_15_33 WBL[33] WWL[15] SN_15_33 GND sg13_hv_nmos W=0.15u L=0.45u
MMS_15_33 MID_15_33 SN_15_33 GND GND sg13_lv_nmos W=0.3u L=0.13u
MMR_15_33 RBL[33] RWL[15] MID_15_33 GND sg13_lv_nmos W=0.3u L=0.13u
MMW_15_34 WBL[34] WWL[15] SN_15_34 GND sg13_hv_nmos W=0.15u L=0.45u
MMS_15_34 MID_15_34 SN_15_34 GND GND sg13_lv_nmos W=0.3u L=0.13u
MMR_15_34 RBL[34] RWL[15] MID_15_34 GND sg13_lv_nmos W=0.3u L=0.13u
MMW_15_35 WBL[35] WWL[15] SN_15_35 GND sg13_hv_nmos W=0.15u L=0.45u
MMS_15_35 MID_15_35 SN_15_35 GND GND sg13_lv_nmos W=0.3u L=0.13u
MMR_15_35 RBL[35] RWL[15] MID_15_35 GND sg13_lv_nmos W=0.3u L=0.13u
MMW_15_36 WBL[36] WWL[15] SN_15_36 GND sg13_hv_nmos W=0.15u L=0.45u
MMS_15_36 MID_15_36 SN_15_36 GND GND sg13_lv_nmos W=0.3u L=0.13u
MMR_15_36 RBL[36] RWL[15] MID_15_36 GND sg13_lv_nmos W=0.3u L=0.13u
MMW_15_37 WBL[37] WWL[15] SN_15_37 GND sg13_hv_nmos W=0.15u L=0.45u
MMS_15_37 MID_15_37 SN_15_37 GND GND sg13_lv_nmos W=0.3u L=0.13u
MMR_15_37 RBL[37] RWL[15] MID_15_37 GND sg13_lv_nmos W=0.3u L=0.13u
MMW_16_0 WBL[0] WWL[16] SN_16_0 GND sg13_hv_nmos W=0.15u L=0.45u
MMS_16_0 MID_16_0 SN_16_0 GND GND sg13_lv_nmos W=0.3u L=0.13u
MMR_16_0 RBL[0] RWL[16] MID_16_0 GND sg13_lv_nmos W=0.3u L=0.13u
MMW_16_1 WBL[1] WWL[16] SN_16_1 GND sg13_hv_nmos W=0.15u L=0.45u
MMS_16_1 MID_16_1 SN_16_1 GND GND sg13_lv_nmos W=0.3u L=0.13u
MMR_16_1 RBL[1] RWL[16] MID_16_1 GND sg13_lv_nmos W=0.3u L=0.13u
MMW_16_2 WBL[2] WWL[16] SN_16_2 GND sg13_hv_nmos W=0.15u L=0.45u
MMS_16_2 MID_16_2 SN_16_2 GND GND sg13_lv_nmos W=0.3u L=0.13u
MMR_16_2 RBL[2] RWL[16] MID_16_2 GND sg13_lv_nmos W=0.3u L=0.13u
MMW_16_3 WBL[3] WWL[16] SN_16_3 GND sg13_hv_nmos W=0.15u L=0.45u
MMS_16_3 MID_16_3 SN_16_3 GND GND sg13_lv_nmos W=0.3u L=0.13u
MMR_16_3 RBL[3] RWL[16] MID_16_3 GND sg13_lv_nmos W=0.3u L=0.13u
MMW_16_4 WBL[4] WWL[16] SN_16_4 GND sg13_hv_nmos W=0.15u L=0.45u
MMS_16_4 MID_16_4 SN_16_4 GND GND sg13_lv_nmos W=0.3u L=0.13u
MMR_16_4 RBL[4] RWL[16] MID_16_4 GND sg13_lv_nmos W=0.3u L=0.13u
MMW_16_5 WBL[5] WWL[16] SN_16_5 GND sg13_hv_nmos W=0.15u L=0.45u
MMS_16_5 MID_16_5 SN_16_5 GND GND sg13_lv_nmos W=0.3u L=0.13u
MMR_16_5 RBL[5] RWL[16] MID_16_5 GND sg13_lv_nmos W=0.3u L=0.13u
MMW_16_6 WBL[6] WWL[16] SN_16_6 GND sg13_hv_nmos W=0.15u L=0.45u
MMS_16_6 MID_16_6 SN_16_6 GND GND sg13_lv_nmos W=0.3u L=0.13u
MMR_16_6 RBL[6] RWL[16] MID_16_6 GND sg13_lv_nmos W=0.3u L=0.13u
MMW_16_7 WBL[7] WWL[16] SN_16_7 GND sg13_hv_nmos W=0.15u L=0.45u
MMS_16_7 MID_16_7 SN_16_7 GND GND sg13_lv_nmos W=0.3u L=0.13u
MMR_16_7 RBL[7] RWL[16] MID_16_7 GND sg13_lv_nmos W=0.3u L=0.13u
MMW_16_8 WBL[8] WWL[16] SN_16_8 GND sg13_hv_nmos W=0.15u L=0.45u
MMS_16_8 MID_16_8 SN_16_8 GND GND sg13_lv_nmos W=0.3u L=0.13u
MMR_16_8 RBL[8] RWL[16] MID_16_8 GND sg13_lv_nmos W=0.3u L=0.13u
MMW_16_9 WBL[9] WWL[16] SN_16_9 GND sg13_hv_nmos W=0.15u L=0.45u
MMS_16_9 MID_16_9 SN_16_9 GND GND sg13_lv_nmos W=0.3u L=0.13u
MMR_16_9 RBL[9] RWL[16] MID_16_9 GND sg13_lv_nmos W=0.3u L=0.13u
MMW_16_10 WBL[10] WWL[16] SN_16_10 GND sg13_hv_nmos W=0.15u L=0.45u
MMS_16_10 MID_16_10 SN_16_10 GND GND sg13_lv_nmos W=0.3u L=0.13u
MMR_16_10 RBL[10] RWL[16] MID_16_10 GND sg13_lv_nmos W=0.3u L=0.13u
MMW_16_11 WBL[11] WWL[16] SN_16_11 GND sg13_hv_nmos W=0.15u L=0.45u
MMS_16_11 MID_16_11 SN_16_11 GND GND sg13_lv_nmos W=0.3u L=0.13u
MMR_16_11 RBL[11] RWL[16] MID_16_11 GND sg13_lv_nmos W=0.3u L=0.13u
MMW_16_12 WBL[12] WWL[16] SN_16_12 GND sg13_hv_nmos W=0.15u L=0.45u
MMS_16_12 MID_16_12 SN_16_12 GND GND sg13_lv_nmos W=0.3u L=0.13u
MMR_16_12 RBL[12] RWL[16] MID_16_12 GND sg13_lv_nmos W=0.3u L=0.13u
MMW_16_13 WBL[13] WWL[16] SN_16_13 GND sg13_hv_nmos W=0.15u L=0.45u
MMS_16_13 MID_16_13 SN_16_13 GND GND sg13_lv_nmos W=0.3u L=0.13u
MMR_16_13 RBL[13] RWL[16] MID_16_13 GND sg13_lv_nmos W=0.3u L=0.13u
MMW_16_14 WBL[14] WWL[16] SN_16_14 GND sg13_hv_nmos W=0.15u L=0.45u
MMS_16_14 MID_16_14 SN_16_14 GND GND sg13_lv_nmos W=0.3u L=0.13u
MMR_16_14 RBL[14] RWL[16] MID_16_14 GND sg13_lv_nmos W=0.3u L=0.13u
MMW_16_15 WBL[15] WWL[16] SN_16_15 GND sg13_hv_nmos W=0.15u L=0.45u
MMS_16_15 MID_16_15 SN_16_15 GND GND sg13_lv_nmos W=0.3u L=0.13u
MMR_16_15 RBL[15] RWL[16] MID_16_15 GND sg13_lv_nmos W=0.3u L=0.13u
MMW_16_16 WBL[16] WWL[16] SN_16_16 GND sg13_hv_nmos W=0.15u L=0.45u
MMS_16_16 MID_16_16 SN_16_16 GND GND sg13_lv_nmos W=0.3u L=0.13u
MMR_16_16 RBL[16] RWL[16] MID_16_16 GND sg13_lv_nmos W=0.3u L=0.13u
MMW_16_17 WBL[17] WWL[16] SN_16_17 GND sg13_hv_nmos W=0.15u L=0.45u
MMS_16_17 MID_16_17 SN_16_17 GND GND sg13_lv_nmos W=0.3u L=0.13u
MMR_16_17 RBL[17] RWL[16] MID_16_17 GND sg13_lv_nmos W=0.3u L=0.13u
MMW_16_18 WBL[18] WWL[16] SN_16_18 GND sg13_hv_nmos W=0.15u L=0.45u
MMS_16_18 MID_16_18 SN_16_18 GND GND sg13_lv_nmos W=0.3u L=0.13u
MMR_16_18 RBL[18] RWL[16] MID_16_18 GND sg13_lv_nmos W=0.3u L=0.13u
MMW_16_19 WBL[19] WWL[16] SN_16_19 GND sg13_hv_nmos W=0.15u L=0.45u
MMS_16_19 MID_16_19 SN_16_19 GND GND sg13_lv_nmos W=0.3u L=0.13u
MMR_16_19 RBL[19] RWL[16] MID_16_19 GND sg13_lv_nmos W=0.3u L=0.13u
MMW_16_20 WBL[20] WWL[16] SN_16_20 GND sg13_hv_nmos W=0.15u L=0.45u
MMS_16_20 MID_16_20 SN_16_20 GND GND sg13_lv_nmos W=0.3u L=0.13u
MMR_16_20 RBL[20] RWL[16] MID_16_20 GND sg13_lv_nmos W=0.3u L=0.13u
MMW_16_21 WBL[21] WWL[16] SN_16_21 GND sg13_hv_nmos W=0.15u L=0.45u
MMS_16_21 MID_16_21 SN_16_21 GND GND sg13_lv_nmos W=0.3u L=0.13u
MMR_16_21 RBL[21] RWL[16] MID_16_21 GND sg13_lv_nmos W=0.3u L=0.13u
MMW_16_22 WBL[22] WWL[16] SN_16_22 GND sg13_hv_nmos W=0.15u L=0.45u
MMS_16_22 MID_16_22 SN_16_22 GND GND sg13_lv_nmos W=0.3u L=0.13u
MMR_16_22 RBL[22] RWL[16] MID_16_22 GND sg13_lv_nmos W=0.3u L=0.13u
MMW_16_23 WBL[23] WWL[16] SN_16_23 GND sg13_hv_nmos W=0.15u L=0.45u
MMS_16_23 MID_16_23 SN_16_23 GND GND sg13_lv_nmos W=0.3u L=0.13u
MMR_16_23 RBL[23] RWL[16] MID_16_23 GND sg13_lv_nmos W=0.3u L=0.13u
MMW_16_24 WBL[24] WWL[16] SN_16_24 GND sg13_hv_nmos W=0.15u L=0.45u
MMS_16_24 MID_16_24 SN_16_24 GND GND sg13_lv_nmos W=0.3u L=0.13u
MMR_16_24 RBL[24] RWL[16] MID_16_24 GND sg13_lv_nmos W=0.3u L=0.13u
MMW_16_25 WBL[25] WWL[16] SN_16_25 GND sg13_hv_nmos W=0.15u L=0.45u
MMS_16_25 MID_16_25 SN_16_25 GND GND sg13_lv_nmos W=0.3u L=0.13u
MMR_16_25 RBL[25] RWL[16] MID_16_25 GND sg13_lv_nmos W=0.3u L=0.13u
MMW_16_26 WBL[26] WWL[16] SN_16_26 GND sg13_hv_nmos W=0.15u L=0.45u
MMS_16_26 MID_16_26 SN_16_26 GND GND sg13_lv_nmos W=0.3u L=0.13u
MMR_16_26 RBL[26] RWL[16] MID_16_26 GND sg13_lv_nmos W=0.3u L=0.13u
MMW_16_27 WBL[27] WWL[16] SN_16_27 GND sg13_hv_nmos W=0.15u L=0.45u
MMS_16_27 MID_16_27 SN_16_27 GND GND sg13_lv_nmos W=0.3u L=0.13u
MMR_16_27 RBL[27] RWL[16] MID_16_27 GND sg13_lv_nmos W=0.3u L=0.13u
MMW_16_28 WBL[28] WWL[16] SN_16_28 GND sg13_hv_nmos W=0.15u L=0.45u
MMS_16_28 MID_16_28 SN_16_28 GND GND sg13_lv_nmos W=0.3u L=0.13u
MMR_16_28 RBL[28] RWL[16] MID_16_28 GND sg13_lv_nmos W=0.3u L=0.13u
MMW_16_29 WBL[29] WWL[16] SN_16_29 GND sg13_hv_nmos W=0.15u L=0.45u
MMS_16_29 MID_16_29 SN_16_29 GND GND sg13_lv_nmos W=0.3u L=0.13u
MMR_16_29 RBL[29] RWL[16] MID_16_29 GND sg13_lv_nmos W=0.3u L=0.13u
MMW_16_30 WBL[30] WWL[16] SN_16_30 GND sg13_hv_nmos W=0.15u L=0.45u
MMS_16_30 MID_16_30 SN_16_30 GND GND sg13_lv_nmos W=0.3u L=0.13u
MMR_16_30 RBL[30] RWL[16] MID_16_30 GND sg13_lv_nmos W=0.3u L=0.13u
MMW_16_31 WBL[31] WWL[16] SN_16_31 GND sg13_hv_nmos W=0.15u L=0.45u
MMS_16_31 MID_16_31 SN_16_31 GND GND sg13_lv_nmos W=0.3u L=0.13u
MMR_16_31 RBL[31] RWL[16] MID_16_31 GND sg13_lv_nmos W=0.3u L=0.13u
MMW_16_32 WBL[32] WWL[16] SN_16_32 GND sg13_hv_nmos W=0.15u L=0.45u
MMS_16_32 MID_16_32 SN_16_32 GND GND sg13_lv_nmos W=0.3u L=0.13u
MMR_16_32 RBL[32] RWL[16] MID_16_32 GND sg13_lv_nmos W=0.3u L=0.13u
MMW_16_33 WBL[33] WWL[16] SN_16_33 GND sg13_hv_nmos W=0.15u L=0.45u
MMS_16_33 MID_16_33 SN_16_33 GND GND sg13_lv_nmos W=0.3u L=0.13u
MMR_16_33 RBL[33] RWL[16] MID_16_33 GND sg13_lv_nmos W=0.3u L=0.13u
MMW_16_34 WBL[34] WWL[16] SN_16_34 GND sg13_hv_nmos W=0.15u L=0.45u
MMS_16_34 MID_16_34 SN_16_34 GND GND sg13_lv_nmos W=0.3u L=0.13u
MMR_16_34 RBL[34] RWL[16] MID_16_34 GND sg13_lv_nmos W=0.3u L=0.13u
MMW_16_35 WBL[35] WWL[16] SN_16_35 GND sg13_hv_nmos W=0.15u L=0.45u
MMS_16_35 MID_16_35 SN_16_35 GND GND sg13_lv_nmos W=0.3u L=0.13u
MMR_16_35 RBL[35] RWL[16] MID_16_35 GND sg13_lv_nmos W=0.3u L=0.13u
MMW_16_36 WBL[36] WWL[16] SN_16_36 GND sg13_hv_nmos W=0.15u L=0.45u
MMS_16_36 MID_16_36 SN_16_36 GND GND sg13_lv_nmos W=0.3u L=0.13u
MMR_16_36 RBL[36] RWL[16] MID_16_36 GND sg13_lv_nmos W=0.3u L=0.13u
MMW_16_37 WBL[37] WWL[16] SN_16_37 GND sg13_hv_nmos W=0.15u L=0.45u
MMS_16_37 MID_16_37 SN_16_37 GND GND sg13_lv_nmos W=0.3u L=0.13u
MMR_16_37 RBL[37] RWL[16] MID_16_37 GND sg13_lv_nmos W=0.3u L=0.13u
MMW_17_0 WBL[0] WWL[17] SN_17_0 GND sg13_hv_nmos W=0.15u L=0.45u
MMS_17_0 MID_17_0 SN_17_0 GND GND sg13_lv_nmos W=0.3u L=0.13u
MMR_17_0 RBL[0] RWL[17] MID_17_0 GND sg13_lv_nmos W=0.3u L=0.13u
MMW_17_1 WBL[1] WWL[17] SN_17_1 GND sg13_hv_nmos W=0.15u L=0.45u
MMS_17_1 MID_17_1 SN_17_1 GND GND sg13_lv_nmos W=0.3u L=0.13u
MMR_17_1 RBL[1] RWL[17] MID_17_1 GND sg13_lv_nmos W=0.3u L=0.13u
MMW_17_2 WBL[2] WWL[17] SN_17_2 GND sg13_hv_nmos W=0.15u L=0.45u
MMS_17_2 MID_17_2 SN_17_2 GND GND sg13_lv_nmos W=0.3u L=0.13u
MMR_17_2 RBL[2] RWL[17] MID_17_2 GND sg13_lv_nmos W=0.3u L=0.13u
MMW_17_3 WBL[3] WWL[17] SN_17_3 GND sg13_hv_nmos W=0.15u L=0.45u
MMS_17_3 MID_17_3 SN_17_3 GND GND sg13_lv_nmos W=0.3u L=0.13u
MMR_17_3 RBL[3] RWL[17] MID_17_3 GND sg13_lv_nmos W=0.3u L=0.13u
MMW_17_4 WBL[4] WWL[17] SN_17_4 GND sg13_hv_nmos W=0.15u L=0.45u
MMS_17_4 MID_17_4 SN_17_4 GND GND sg13_lv_nmos W=0.3u L=0.13u
MMR_17_4 RBL[4] RWL[17] MID_17_4 GND sg13_lv_nmos W=0.3u L=0.13u
MMW_17_5 WBL[5] WWL[17] SN_17_5 GND sg13_hv_nmos W=0.15u L=0.45u
MMS_17_5 MID_17_5 SN_17_5 GND GND sg13_lv_nmos W=0.3u L=0.13u
MMR_17_5 RBL[5] RWL[17] MID_17_5 GND sg13_lv_nmos W=0.3u L=0.13u
MMW_17_6 WBL[6] WWL[17] SN_17_6 GND sg13_hv_nmos W=0.15u L=0.45u
MMS_17_6 MID_17_6 SN_17_6 GND GND sg13_lv_nmos W=0.3u L=0.13u
MMR_17_6 RBL[6] RWL[17] MID_17_6 GND sg13_lv_nmos W=0.3u L=0.13u
MMW_17_7 WBL[7] WWL[17] SN_17_7 GND sg13_hv_nmos W=0.15u L=0.45u
MMS_17_7 MID_17_7 SN_17_7 GND GND sg13_lv_nmos W=0.3u L=0.13u
MMR_17_7 RBL[7] RWL[17] MID_17_7 GND sg13_lv_nmos W=0.3u L=0.13u
MMW_17_8 WBL[8] WWL[17] SN_17_8 GND sg13_hv_nmos W=0.15u L=0.45u
MMS_17_8 MID_17_8 SN_17_8 GND GND sg13_lv_nmos W=0.3u L=0.13u
MMR_17_8 RBL[8] RWL[17] MID_17_8 GND sg13_lv_nmos W=0.3u L=0.13u
MMW_17_9 WBL[9] WWL[17] SN_17_9 GND sg13_hv_nmos W=0.15u L=0.45u
MMS_17_9 MID_17_9 SN_17_9 GND GND sg13_lv_nmos W=0.3u L=0.13u
MMR_17_9 RBL[9] RWL[17] MID_17_9 GND sg13_lv_nmos W=0.3u L=0.13u
MMW_17_10 WBL[10] WWL[17] SN_17_10 GND sg13_hv_nmos W=0.15u L=0.45u
MMS_17_10 MID_17_10 SN_17_10 GND GND sg13_lv_nmos W=0.3u L=0.13u
MMR_17_10 RBL[10] RWL[17] MID_17_10 GND sg13_lv_nmos W=0.3u L=0.13u
MMW_17_11 WBL[11] WWL[17] SN_17_11 GND sg13_hv_nmos W=0.15u L=0.45u
MMS_17_11 MID_17_11 SN_17_11 GND GND sg13_lv_nmos W=0.3u L=0.13u
MMR_17_11 RBL[11] RWL[17] MID_17_11 GND sg13_lv_nmos W=0.3u L=0.13u
MMW_17_12 WBL[12] WWL[17] SN_17_12 GND sg13_hv_nmos W=0.15u L=0.45u
MMS_17_12 MID_17_12 SN_17_12 GND GND sg13_lv_nmos W=0.3u L=0.13u
MMR_17_12 RBL[12] RWL[17] MID_17_12 GND sg13_lv_nmos W=0.3u L=0.13u
MMW_17_13 WBL[13] WWL[17] SN_17_13 GND sg13_hv_nmos W=0.15u L=0.45u
MMS_17_13 MID_17_13 SN_17_13 GND GND sg13_lv_nmos W=0.3u L=0.13u
MMR_17_13 RBL[13] RWL[17] MID_17_13 GND sg13_lv_nmos W=0.3u L=0.13u
MMW_17_14 WBL[14] WWL[17] SN_17_14 GND sg13_hv_nmos W=0.15u L=0.45u
MMS_17_14 MID_17_14 SN_17_14 GND GND sg13_lv_nmos W=0.3u L=0.13u
MMR_17_14 RBL[14] RWL[17] MID_17_14 GND sg13_lv_nmos W=0.3u L=0.13u
MMW_17_15 WBL[15] WWL[17] SN_17_15 GND sg13_hv_nmos W=0.15u L=0.45u
MMS_17_15 MID_17_15 SN_17_15 GND GND sg13_lv_nmos W=0.3u L=0.13u
MMR_17_15 RBL[15] RWL[17] MID_17_15 GND sg13_lv_nmos W=0.3u L=0.13u
MMW_17_16 WBL[16] WWL[17] SN_17_16 GND sg13_hv_nmos W=0.15u L=0.45u
MMS_17_16 MID_17_16 SN_17_16 GND GND sg13_lv_nmos W=0.3u L=0.13u
MMR_17_16 RBL[16] RWL[17] MID_17_16 GND sg13_lv_nmos W=0.3u L=0.13u
MMW_17_17 WBL[17] WWL[17] SN_17_17 GND sg13_hv_nmos W=0.15u L=0.45u
MMS_17_17 MID_17_17 SN_17_17 GND GND sg13_lv_nmos W=0.3u L=0.13u
MMR_17_17 RBL[17] RWL[17] MID_17_17 GND sg13_lv_nmos W=0.3u L=0.13u
MMW_17_18 WBL[18] WWL[17] SN_17_18 GND sg13_hv_nmos W=0.15u L=0.45u
MMS_17_18 MID_17_18 SN_17_18 GND GND sg13_lv_nmos W=0.3u L=0.13u
MMR_17_18 RBL[18] RWL[17] MID_17_18 GND sg13_lv_nmos W=0.3u L=0.13u
MMW_17_19 WBL[19] WWL[17] SN_17_19 GND sg13_hv_nmos W=0.15u L=0.45u
MMS_17_19 MID_17_19 SN_17_19 GND GND sg13_lv_nmos W=0.3u L=0.13u
MMR_17_19 RBL[19] RWL[17] MID_17_19 GND sg13_lv_nmos W=0.3u L=0.13u
MMW_17_20 WBL[20] WWL[17] SN_17_20 GND sg13_hv_nmos W=0.15u L=0.45u
MMS_17_20 MID_17_20 SN_17_20 GND GND sg13_lv_nmos W=0.3u L=0.13u
MMR_17_20 RBL[20] RWL[17] MID_17_20 GND sg13_lv_nmos W=0.3u L=0.13u
MMW_17_21 WBL[21] WWL[17] SN_17_21 GND sg13_hv_nmos W=0.15u L=0.45u
MMS_17_21 MID_17_21 SN_17_21 GND GND sg13_lv_nmos W=0.3u L=0.13u
MMR_17_21 RBL[21] RWL[17] MID_17_21 GND sg13_lv_nmos W=0.3u L=0.13u
MMW_17_22 WBL[22] WWL[17] SN_17_22 GND sg13_hv_nmos W=0.15u L=0.45u
MMS_17_22 MID_17_22 SN_17_22 GND GND sg13_lv_nmos W=0.3u L=0.13u
MMR_17_22 RBL[22] RWL[17] MID_17_22 GND sg13_lv_nmos W=0.3u L=0.13u
MMW_17_23 WBL[23] WWL[17] SN_17_23 GND sg13_hv_nmos W=0.15u L=0.45u
MMS_17_23 MID_17_23 SN_17_23 GND GND sg13_lv_nmos W=0.3u L=0.13u
MMR_17_23 RBL[23] RWL[17] MID_17_23 GND sg13_lv_nmos W=0.3u L=0.13u
MMW_17_24 WBL[24] WWL[17] SN_17_24 GND sg13_hv_nmos W=0.15u L=0.45u
MMS_17_24 MID_17_24 SN_17_24 GND GND sg13_lv_nmos W=0.3u L=0.13u
MMR_17_24 RBL[24] RWL[17] MID_17_24 GND sg13_lv_nmos W=0.3u L=0.13u
MMW_17_25 WBL[25] WWL[17] SN_17_25 GND sg13_hv_nmos W=0.15u L=0.45u
MMS_17_25 MID_17_25 SN_17_25 GND GND sg13_lv_nmos W=0.3u L=0.13u
MMR_17_25 RBL[25] RWL[17] MID_17_25 GND sg13_lv_nmos W=0.3u L=0.13u
MMW_17_26 WBL[26] WWL[17] SN_17_26 GND sg13_hv_nmos W=0.15u L=0.45u
MMS_17_26 MID_17_26 SN_17_26 GND GND sg13_lv_nmos W=0.3u L=0.13u
MMR_17_26 RBL[26] RWL[17] MID_17_26 GND sg13_lv_nmos W=0.3u L=0.13u
MMW_17_27 WBL[27] WWL[17] SN_17_27 GND sg13_hv_nmos W=0.15u L=0.45u
MMS_17_27 MID_17_27 SN_17_27 GND GND sg13_lv_nmos W=0.3u L=0.13u
MMR_17_27 RBL[27] RWL[17] MID_17_27 GND sg13_lv_nmos W=0.3u L=0.13u
MMW_17_28 WBL[28] WWL[17] SN_17_28 GND sg13_hv_nmos W=0.15u L=0.45u
MMS_17_28 MID_17_28 SN_17_28 GND GND sg13_lv_nmos W=0.3u L=0.13u
MMR_17_28 RBL[28] RWL[17] MID_17_28 GND sg13_lv_nmos W=0.3u L=0.13u
MMW_17_29 WBL[29] WWL[17] SN_17_29 GND sg13_hv_nmos W=0.15u L=0.45u
MMS_17_29 MID_17_29 SN_17_29 GND GND sg13_lv_nmos W=0.3u L=0.13u
MMR_17_29 RBL[29] RWL[17] MID_17_29 GND sg13_lv_nmos W=0.3u L=0.13u
MMW_17_30 WBL[30] WWL[17] SN_17_30 GND sg13_hv_nmos W=0.15u L=0.45u
MMS_17_30 MID_17_30 SN_17_30 GND GND sg13_lv_nmos W=0.3u L=0.13u
MMR_17_30 RBL[30] RWL[17] MID_17_30 GND sg13_lv_nmos W=0.3u L=0.13u
MMW_17_31 WBL[31] WWL[17] SN_17_31 GND sg13_hv_nmos W=0.15u L=0.45u
MMS_17_31 MID_17_31 SN_17_31 GND GND sg13_lv_nmos W=0.3u L=0.13u
MMR_17_31 RBL[31] RWL[17] MID_17_31 GND sg13_lv_nmos W=0.3u L=0.13u
MMW_17_32 WBL[32] WWL[17] SN_17_32 GND sg13_hv_nmos W=0.15u L=0.45u
MMS_17_32 MID_17_32 SN_17_32 GND GND sg13_lv_nmos W=0.3u L=0.13u
MMR_17_32 RBL[32] RWL[17] MID_17_32 GND sg13_lv_nmos W=0.3u L=0.13u
MMW_17_33 WBL[33] WWL[17] SN_17_33 GND sg13_hv_nmos W=0.15u L=0.45u
MMS_17_33 MID_17_33 SN_17_33 GND GND sg13_lv_nmos W=0.3u L=0.13u
MMR_17_33 RBL[33] RWL[17] MID_17_33 GND sg13_lv_nmos W=0.3u L=0.13u
MMW_17_34 WBL[34] WWL[17] SN_17_34 GND sg13_hv_nmos W=0.15u L=0.45u
MMS_17_34 MID_17_34 SN_17_34 GND GND sg13_lv_nmos W=0.3u L=0.13u
MMR_17_34 RBL[34] RWL[17] MID_17_34 GND sg13_lv_nmos W=0.3u L=0.13u
MMW_17_35 WBL[35] WWL[17] SN_17_35 GND sg13_hv_nmos W=0.15u L=0.45u
MMS_17_35 MID_17_35 SN_17_35 GND GND sg13_lv_nmos W=0.3u L=0.13u
MMR_17_35 RBL[35] RWL[17] MID_17_35 GND sg13_lv_nmos W=0.3u L=0.13u
MMW_17_36 WBL[36] WWL[17] SN_17_36 GND sg13_hv_nmos W=0.15u L=0.45u
MMS_17_36 MID_17_36 SN_17_36 GND GND sg13_lv_nmos W=0.3u L=0.13u
MMR_17_36 RBL[36] RWL[17] MID_17_36 GND sg13_lv_nmos W=0.3u L=0.13u
MMW_17_37 WBL[37] WWL[17] SN_17_37 GND sg13_hv_nmos W=0.15u L=0.45u
MMS_17_37 MID_17_37 SN_17_37 GND GND sg13_lv_nmos W=0.3u L=0.13u
MMR_17_37 RBL[37] RWL[17] MID_17_37 GND sg13_lv_nmos W=0.3u L=0.13u
MMW_18_0 WBL[0] WWL[18] SN_18_0 GND sg13_hv_nmos W=0.15u L=0.45u
MMS_18_0 MID_18_0 SN_18_0 GND GND sg13_lv_nmos W=0.3u L=0.13u
MMR_18_0 RBL[0] RWL[18] MID_18_0 GND sg13_lv_nmos W=0.3u L=0.13u
MMW_18_1 WBL[1] WWL[18] SN_18_1 GND sg13_hv_nmos W=0.15u L=0.45u
MMS_18_1 MID_18_1 SN_18_1 GND GND sg13_lv_nmos W=0.3u L=0.13u
MMR_18_1 RBL[1] RWL[18] MID_18_1 GND sg13_lv_nmos W=0.3u L=0.13u
MMW_18_2 WBL[2] WWL[18] SN_18_2 GND sg13_hv_nmos W=0.15u L=0.45u
MMS_18_2 MID_18_2 SN_18_2 GND GND sg13_lv_nmos W=0.3u L=0.13u
MMR_18_2 RBL[2] RWL[18] MID_18_2 GND sg13_lv_nmos W=0.3u L=0.13u
MMW_18_3 WBL[3] WWL[18] SN_18_3 GND sg13_hv_nmos W=0.15u L=0.45u
MMS_18_3 MID_18_3 SN_18_3 GND GND sg13_lv_nmos W=0.3u L=0.13u
MMR_18_3 RBL[3] RWL[18] MID_18_3 GND sg13_lv_nmos W=0.3u L=0.13u
MMW_18_4 WBL[4] WWL[18] SN_18_4 GND sg13_hv_nmos W=0.15u L=0.45u
MMS_18_4 MID_18_4 SN_18_4 GND GND sg13_lv_nmos W=0.3u L=0.13u
MMR_18_4 RBL[4] RWL[18] MID_18_4 GND sg13_lv_nmos W=0.3u L=0.13u
MMW_18_5 WBL[5] WWL[18] SN_18_5 GND sg13_hv_nmos W=0.15u L=0.45u
MMS_18_5 MID_18_5 SN_18_5 GND GND sg13_lv_nmos W=0.3u L=0.13u
MMR_18_5 RBL[5] RWL[18] MID_18_5 GND sg13_lv_nmos W=0.3u L=0.13u
MMW_18_6 WBL[6] WWL[18] SN_18_6 GND sg13_hv_nmos W=0.15u L=0.45u
MMS_18_6 MID_18_6 SN_18_6 GND GND sg13_lv_nmos W=0.3u L=0.13u
MMR_18_6 RBL[6] RWL[18] MID_18_6 GND sg13_lv_nmos W=0.3u L=0.13u
MMW_18_7 WBL[7] WWL[18] SN_18_7 GND sg13_hv_nmos W=0.15u L=0.45u
MMS_18_7 MID_18_7 SN_18_7 GND GND sg13_lv_nmos W=0.3u L=0.13u
MMR_18_7 RBL[7] RWL[18] MID_18_7 GND sg13_lv_nmos W=0.3u L=0.13u
MMW_18_8 WBL[8] WWL[18] SN_18_8 GND sg13_hv_nmos W=0.15u L=0.45u
MMS_18_8 MID_18_8 SN_18_8 GND GND sg13_lv_nmos W=0.3u L=0.13u
MMR_18_8 RBL[8] RWL[18] MID_18_8 GND sg13_lv_nmos W=0.3u L=0.13u
MMW_18_9 WBL[9] WWL[18] SN_18_9 GND sg13_hv_nmos W=0.15u L=0.45u
MMS_18_9 MID_18_9 SN_18_9 GND GND sg13_lv_nmos W=0.3u L=0.13u
MMR_18_9 RBL[9] RWL[18] MID_18_9 GND sg13_lv_nmos W=0.3u L=0.13u
MMW_18_10 WBL[10] WWL[18] SN_18_10 GND sg13_hv_nmos W=0.15u L=0.45u
MMS_18_10 MID_18_10 SN_18_10 GND GND sg13_lv_nmos W=0.3u L=0.13u
MMR_18_10 RBL[10] RWL[18] MID_18_10 GND sg13_lv_nmos W=0.3u L=0.13u
MMW_18_11 WBL[11] WWL[18] SN_18_11 GND sg13_hv_nmos W=0.15u L=0.45u
MMS_18_11 MID_18_11 SN_18_11 GND GND sg13_lv_nmos W=0.3u L=0.13u
MMR_18_11 RBL[11] RWL[18] MID_18_11 GND sg13_lv_nmos W=0.3u L=0.13u
MMW_18_12 WBL[12] WWL[18] SN_18_12 GND sg13_hv_nmos W=0.15u L=0.45u
MMS_18_12 MID_18_12 SN_18_12 GND GND sg13_lv_nmos W=0.3u L=0.13u
MMR_18_12 RBL[12] RWL[18] MID_18_12 GND sg13_lv_nmos W=0.3u L=0.13u
MMW_18_13 WBL[13] WWL[18] SN_18_13 GND sg13_hv_nmos W=0.15u L=0.45u
MMS_18_13 MID_18_13 SN_18_13 GND GND sg13_lv_nmos W=0.3u L=0.13u
MMR_18_13 RBL[13] RWL[18] MID_18_13 GND sg13_lv_nmos W=0.3u L=0.13u
MMW_18_14 WBL[14] WWL[18] SN_18_14 GND sg13_hv_nmos W=0.15u L=0.45u
MMS_18_14 MID_18_14 SN_18_14 GND GND sg13_lv_nmos W=0.3u L=0.13u
MMR_18_14 RBL[14] RWL[18] MID_18_14 GND sg13_lv_nmos W=0.3u L=0.13u
MMW_18_15 WBL[15] WWL[18] SN_18_15 GND sg13_hv_nmos W=0.15u L=0.45u
MMS_18_15 MID_18_15 SN_18_15 GND GND sg13_lv_nmos W=0.3u L=0.13u
MMR_18_15 RBL[15] RWL[18] MID_18_15 GND sg13_lv_nmos W=0.3u L=0.13u
MMW_18_16 WBL[16] WWL[18] SN_18_16 GND sg13_hv_nmos W=0.15u L=0.45u
MMS_18_16 MID_18_16 SN_18_16 GND GND sg13_lv_nmos W=0.3u L=0.13u
MMR_18_16 RBL[16] RWL[18] MID_18_16 GND sg13_lv_nmos W=0.3u L=0.13u
MMW_18_17 WBL[17] WWL[18] SN_18_17 GND sg13_hv_nmos W=0.15u L=0.45u
MMS_18_17 MID_18_17 SN_18_17 GND GND sg13_lv_nmos W=0.3u L=0.13u
MMR_18_17 RBL[17] RWL[18] MID_18_17 GND sg13_lv_nmos W=0.3u L=0.13u
MMW_18_18 WBL[18] WWL[18] SN_18_18 GND sg13_hv_nmos W=0.15u L=0.45u
MMS_18_18 MID_18_18 SN_18_18 GND GND sg13_lv_nmos W=0.3u L=0.13u
MMR_18_18 RBL[18] RWL[18] MID_18_18 GND sg13_lv_nmos W=0.3u L=0.13u
MMW_18_19 WBL[19] WWL[18] SN_18_19 GND sg13_hv_nmos W=0.15u L=0.45u
MMS_18_19 MID_18_19 SN_18_19 GND GND sg13_lv_nmos W=0.3u L=0.13u
MMR_18_19 RBL[19] RWL[18] MID_18_19 GND sg13_lv_nmos W=0.3u L=0.13u
MMW_18_20 WBL[20] WWL[18] SN_18_20 GND sg13_hv_nmos W=0.15u L=0.45u
MMS_18_20 MID_18_20 SN_18_20 GND GND sg13_lv_nmos W=0.3u L=0.13u
MMR_18_20 RBL[20] RWL[18] MID_18_20 GND sg13_lv_nmos W=0.3u L=0.13u
MMW_18_21 WBL[21] WWL[18] SN_18_21 GND sg13_hv_nmos W=0.15u L=0.45u
MMS_18_21 MID_18_21 SN_18_21 GND GND sg13_lv_nmos W=0.3u L=0.13u
MMR_18_21 RBL[21] RWL[18] MID_18_21 GND sg13_lv_nmos W=0.3u L=0.13u
MMW_18_22 WBL[22] WWL[18] SN_18_22 GND sg13_hv_nmos W=0.15u L=0.45u
MMS_18_22 MID_18_22 SN_18_22 GND GND sg13_lv_nmos W=0.3u L=0.13u
MMR_18_22 RBL[22] RWL[18] MID_18_22 GND sg13_lv_nmos W=0.3u L=0.13u
MMW_18_23 WBL[23] WWL[18] SN_18_23 GND sg13_hv_nmos W=0.15u L=0.45u
MMS_18_23 MID_18_23 SN_18_23 GND GND sg13_lv_nmos W=0.3u L=0.13u
MMR_18_23 RBL[23] RWL[18] MID_18_23 GND sg13_lv_nmos W=0.3u L=0.13u
MMW_18_24 WBL[24] WWL[18] SN_18_24 GND sg13_hv_nmos W=0.15u L=0.45u
MMS_18_24 MID_18_24 SN_18_24 GND GND sg13_lv_nmos W=0.3u L=0.13u
MMR_18_24 RBL[24] RWL[18] MID_18_24 GND sg13_lv_nmos W=0.3u L=0.13u
MMW_18_25 WBL[25] WWL[18] SN_18_25 GND sg13_hv_nmos W=0.15u L=0.45u
MMS_18_25 MID_18_25 SN_18_25 GND GND sg13_lv_nmos W=0.3u L=0.13u
MMR_18_25 RBL[25] RWL[18] MID_18_25 GND sg13_lv_nmos W=0.3u L=0.13u
MMW_18_26 WBL[26] WWL[18] SN_18_26 GND sg13_hv_nmos W=0.15u L=0.45u
MMS_18_26 MID_18_26 SN_18_26 GND GND sg13_lv_nmos W=0.3u L=0.13u
MMR_18_26 RBL[26] RWL[18] MID_18_26 GND sg13_lv_nmos W=0.3u L=0.13u
MMW_18_27 WBL[27] WWL[18] SN_18_27 GND sg13_hv_nmos W=0.15u L=0.45u
MMS_18_27 MID_18_27 SN_18_27 GND GND sg13_lv_nmos W=0.3u L=0.13u
MMR_18_27 RBL[27] RWL[18] MID_18_27 GND sg13_lv_nmos W=0.3u L=0.13u
MMW_18_28 WBL[28] WWL[18] SN_18_28 GND sg13_hv_nmos W=0.15u L=0.45u
MMS_18_28 MID_18_28 SN_18_28 GND GND sg13_lv_nmos W=0.3u L=0.13u
MMR_18_28 RBL[28] RWL[18] MID_18_28 GND sg13_lv_nmos W=0.3u L=0.13u
MMW_18_29 WBL[29] WWL[18] SN_18_29 GND sg13_hv_nmos W=0.15u L=0.45u
MMS_18_29 MID_18_29 SN_18_29 GND GND sg13_lv_nmos W=0.3u L=0.13u
MMR_18_29 RBL[29] RWL[18] MID_18_29 GND sg13_lv_nmos W=0.3u L=0.13u
MMW_18_30 WBL[30] WWL[18] SN_18_30 GND sg13_hv_nmos W=0.15u L=0.45u
MMS_18_30 MID_18_30 SN_18_30 GND GND sg13_lv_nmos W=0.3u L=0.13u
MMR_18_30 RBL[30] RWL[18] MID_18_30 GND sg13_lv_nmos W=0.3u L=0.13u
MMW_18_31 WBL[31] WWL[18] SN_18_31 GND sg13_hv_nmos W=0.15u L=0.45u
MMS_18_31 MID_18_31 SN_18_31 GND GND sg13_lv_nmos W=0.3u L=0.13u
MMR_18_31 RBL[31] RWL[18] MID_18_31 GND sg13_lv_nmos W=0.3u L=0.13u
MMW_18_32 WBL[32] WWL[18] SN_18_32 GND sg13_hv_nmos W=0.15u L=0.45u
MMS_18_32 MID_18_32 SN_18_32 GND GND sg13_lv_nmos W=0.3u L=0.13u
MMR_18_32 RBL[32] RWL[18] MID_18_32 GND sg13_lv_nmos W=0.3u L=0.13u
MMW_18_33 WBL[33] WWL[18] SN_18_33 GND sg13_hv_nmos W=0.15u L=0.45u
MMS_18_33 MID_18_33 SN_18_33 GND GND sg13_lv_nmos W=0.3u L=0.13u
MMR_18_33 RBL[33] RWL[18] MID_18_33 GND sg13_lv_nmos W=0.3u L=0.13u
MMW_18_34 WBL[34] WWL[18] SN_18_34 GND sg13_hv_nmos W=0.15u L=0.45u
MMS_18_34 MID_18_34 SN_18_34 GND GND sg13_lv_nmos W=0.3u L=0.13u
MMR_18_34 RBL[34] RWL[18] MID_18_34 GND sg13_lv_nmos W=0.3u L=0.13u
MMW_18_35 WBL[35] WWL[18] SN_18_35 GND sg13_hv_nmos W=0.15u L=0.45u
MMS_18_35 MID_18_35 SN_18_35 GND GND sg13_lv_nmos W=0.3u L=0.13u
MMR_18_35 RBL[35] RWL[18] MID_18_35 GND sg13_lv_nmos W=0.3u L=0.13u
MMW_18_36 WBL[36] WWL[18] SN_18_36 GND sg13_hv_nmos W=0.15u L=0.45u
MMS_18_36 MID_18_36 SN_18_36 GND GND sg13_lv_nmos W=0.3u L=0.13u
MMR_18_36 RBL[36] RWL[18] MID_18_36 GND sg13_lv_nmos W=0.3u L=0.13u
MMW_18_37 WBL[37] WWL[18] SN_18_37 GND sg13_hv_nmos W=0.15u L=0.45u
MMS_18_37 MID_18_37 SN_18_37 GND GND sg13_lv_nmos W=0.3u L=0.13u
MMR_18_37 RBL[37] RWL[18] MID_18_37 GND sg13_lv_nmos W=0.3u L=0.13u
MMW_19_0 WBL[0] WWL[19] SN_19_0 GND sg13_hv_nmos W=0.15u L=0.45u
MMS_19_0 MID_19_0 SN_19_0 GND GND sg13_lv_nmos W=0.3u L=0.13u
MMR_19_0 RBL[0] RWL[19] MID_19_0 GND sg13_lv_nmos W=0.3u L=0.13u
MMW_19_1 WBL[1] WWL[19] SN_19_1 GND sg13_hv_nmos W=0.15u L=0.45u
MMS_19_1 MID_19_1 SN_19_1 GND GND sg13_lv_nmos W=0.3u L=0.13u
MMR_19_1 RBL[1] RWL[19] MID_19_1 GND sg13_lv_nmos W=0.3u L=0.13u
MMW_19_2 WBL[2] WWL[19] SN_19_2 GND sg13_hv_nmos W=0.15u L=0.45u
MMS_19_2 MID_19_2 SN_19_2 GND GND sg13_lv_nmos W=0.3u L=0.13u
MMR_19_2 RBL[2] RWL[19] MID_19_2 GND sg13_lv_nmos W=0.3u L=0.13u
MMW_19_3 WBL[3] WWL[19] SN_19_3 GND sg13_hv_nmos W=0.15u L=0.45u
MMS_19_3 MID_19_3 SN_19_3 GND GND sg13_lv_nmos W=0.3u L=0.13u
MMR_19_3 RBL[3] RWL[19] MID_19_3 GND sg13_lv_nmos W=0.3u L=0.13u
MMW_19_4 WBL[4] WWL[19] SN_19_4 GND sg13_hv_nmos W=0.15u L=0.45u
MMS_19_4 MID_19_4 SN_19_4 GND GND sg13_lv_nmos W=0.3u L=0.13u
MMR_19_4 RBL[4] RWL[19] MID_19_4 GND sg13_lv_nmos W=0.3u L=0.13u
MMW_19_5 WBL[5] WWL[19] SN_19_5 GND sg13_hv_nmos W=0.15u L=0.45u
MMS_19_5 MID_19_5 SN_19_5 GND GND sg13_lv_nmos W=0.3u L=0.13u
MMR_19_5 RBL[5] RWL[19] MID_19_5 GND sg13_lv_nmos W=0.3u L=0.13u
MMW_19_6 WBL[6] WWL[19] SN_19_6 GND sg13_hv_nmos W=0.15u L=0.45u
MMS_19_6 MID_19_6 SN_19_6 GND GND sg13_lv_nmos W=0.3u L=0.13u
MMR_19_6 RBL[6] RWL[19] MID_19_6 GND sg13_lv_nmos W=0.3u L=0.13u
MMW_19_7 WBL[7] WWL[19] SN_19_7 GND sg13_hv_nmos W=0.15u L=0.45u
MMS_19_7 MID_19_7 SN_19_7 GND GND sg13_lv_nmos W=0.3u L=0.13u
MMR_19_7 RBL[7] RWL[19] MID_19_7 GND sg13_lv_nmos W=0.3u L=0.13u
MMW_19_8 WBL[8] WWL[19] SN_19_8 GND sg13_hv_nmos W=0.15u L=0.45u
MMS_19_8 MID_19_8 SN_19_8 GND GND sg13_lv_nmos W=0.3u L=0.13u
MMR_19_8 RBL[8] RWL[19] MID_19_8 GND sg13_lv_nmos W=0.3u L=0.13u
MMW_19_9 WBL[9] WWL[19] SN_19_9 GND sg13_hv_nmos W=0.15u L=0.45u
MMS_19_9 MID_19_9 SN_19_9 GND GND sg13_lv_nmos W=0.3u L=0.13u
MMR_19_9 RBL[9] RWL[19] MID_19_9 GND sg13_lv_nmos W=0.3u L=0.13u
MMW_19_10 WBL[10] WWL[19] SN_19_10 GND sg13_hv_nmos W=0.15u L=0.45u
MMS_19_10 MID_19_10 SN_19_10 GND GND sg13_lv_nmos W=0.3u L=0.13u
MMR_19_10 RBL[10] RWL[19] MID_19_10 GND sg13_lv_nmos W=0.3u L=0.13u
MMW_19_11 WBL[11] WWL[19] SN_19_11 GND sg13_hv_nmos W=0.15u L=0.45u
MMS_19_11 MID_19_11 SN_19_11 GND GND sg13_lv_nmos W=0.3u L=0.13u
MMR_19_11 RBL[11] RWL[19] MID_19_11 GND sg13_lv_nmos W=0.3u L=0.13u
MMW_19_12 WBL[12] WWL[19] SN_19_12 GND sg13_hv_nmos W=0.15u L=0.45u
MMS_19_12 MID_19_12 SN_19_12 GND GND sg13_lv_nmos W=0.3u L=0.13u
MMR_19_12 RBL[12] RWL[19] MID_19_12 GND sg13_lv_nmos W=0.3u L=0.13u
MMW_19_13 WBL[13] WWL[19] SN_19_13 GND sg13_hv_nmos W=0.15u L=0.45u
MMS_19_13 MID_19_13 SN_19_13 GND GND sg13_lv_nmos W=0.3u L=0.13u
MMR_19_13 RBL[13] RWL[19] MID_19_13 GND sg13_lv_nmos W=0.3u L=0.13u
MMW_19_14 WBL[14] WWL[19] SN_19_14 GND sg13_hv_nmos W=0.15u L=0.45u
MMS_19_14 MID_19_14 SN_19_14 GND GND sg13_lv_nmos W=0.3u L=0.13u
MMR_19_14 RBL[14] RWL[19] MID_19_14 GND sg13_lv_nmos W=0.3u L=0.13u
MMW_19_15 WBL[15] WWL[19] SN_19_15 GND sg13_hv_nmos W=0.15u L=0.45u
MMS_19_15 MID_19_15 SN_19_15 GND GND sg13_lv_nmos W=0.3u L=0.13u
MMR_19_15 RBL[15] RWL[19] MID_19_15 GND sg13_lv_nmos W=0.3u L=0.13u
MMW_19_16 WBL[16] WWL[19] SN_19_16 GND sg13_hv_nmos W=0.15u L=0.45u
MMS_19_16 MID_19_16 SN_19_16 GND GND sg13_lv_nmos W=0.3u L=0.13u
MMR_19_16 RBL[16] RWL[19] MID_19_16 GND sg13_lv_nmos W=0.3u L=0.13u
MMW_19_17 WBL[17] WWL[19] SN_19_17 GND sg13_hv_nmos W=0.15u L=0.45u
MMS_19_17 MID_19_17 SN_19_17 GND GND sg13_lv_nmos W=0.3u L=0.13u
MMR_19_17 RBL[17] RWL[19] MID_19_17 GND sg13_lv_nmos W=0.3u L=0.13u
MMW_19_18 WBL[18] WWL[19] SN_19_18 GND sg13_hv_nmos W=0.15u L=0.45u
MMS_19_18 MID_19_18 SN_19_18 GND GND sg13_lv_nmos W=0.3u L=0.13u
MMR_19_18 RBL[18] RWL[19] MID_19_18 GND sg13_lv_nmos W=0.3u L=0.13u
MMW_19_19 WBL[19] WWL[19] SN_19_19 GND sg13_hv_nmos W=0.15u L=0.45u
MMS_19_19 MID_19_19 SN_19_19 GND GND sg13_lv_nmos W=0.3u L=0.13u
MMR_19_19 RBL[19] RWL[19] MID_19_19 GND sg13_lv_nmos W=0.3u L=0.13u
MMW_19_20 WBL[20] WWL[19] SN_19_20 GND sg13_hv_nmos W=0.15u L=0.45u
MMS_19_20 MID_19_20 SN_19_20 GND GND sg13_lv_nmos W=0.3u L=0.13u
MMR_19_20 RBL[20] RWL[19] MID_19_20 GND sg13_lv_nmos W=0.3u L=0.13u
MMW_19_21 WBL[21] WWL[19] SN_19_21 GND sg13_hv_nmos W=0.15u L=0.45u
MMS_19_21 MID_19_21 SN_19_21 GND GND sg13_lv_nmos W=0.3u L=0.13u
MMR_19_21 RBL[21] RWL[19] MID_19_21 GND sg13_lv_nmos W=0.3u L=0.13u
MMW_19_22 WBL[22] WWL[19] SN_19_22 GND sg13_hv_nmos W=0.15u L=0.45u
MMS_19_22 MID_19_22 SN_19_22 GND GND sg13_lv_nmos W=0.3u L=0.13u
MMR_19_22 RBL[22] RWL[19] MID_19_22 GND sg13_lv_nmos W=0.3u L=0.13u
MMW_19_23 WBL[23] WWL[19] SN_19_23 GND sg13_hv_nmos W=0.15u L=0.45u
MMS_19_23 MID_19_23 SN_19_23 GND GND sg13_lv_nmos W=0.3u L=0.13u
MMR_19_23 RBL[23] RWL[19] MID_19_23 GND sg13_lv_nmos W=0.3u L=0.13u
MMW_19_24 WBL[24] WWL[19] SN_19_24 GND sg13_hv_nmos W=0.15u L=0.45u
MMS_19_24 MID_19_24 SN_19_24 GND GND sg13_lv_nmos W=0.3u L=0.13u
MMR_19_24 RBL[24] RWL[19] MID_19_24 GND sg13_lv_nmos W=0.3u L=0.13u
MMW_19_25 WBL[25] WWL[19] SN_19_25 GND sg13_hv_nmos W=0.15u L=0.45u
MMS_19_25 MID_19_25 SN_19_25 GND GND sg13_lv_nmos W=0.3u L=0.13u
MMR_19_25 RBL[25] RWL[19] MID_19_25 GND sg13_lv_nmos W=0.3u L=0.13u
MMW_19_26 WBL[26] WWL[19] SN_19_26 GND sg13_hv_nmos W=0.15u L=0.45u
MMS_19_26 MID_19_26 SN_19_26 GND GND sg13_lv_nmos W=0.3u L=0.13u
MMR_19_26 RBL[26] RWL[19] MID_19_26 GND sg13_lv_nmos W=0.3u L=0.13u
MMW_19_27 WBL[27] WWL[19] SN_19_27 GND sg13_hv_nmos W=0.15u L=0.45u
MMS_19_27 MID_19_27 SN_19_27 GND GND sg13_lv_nmos W=0.3u L=0.13u
MMR_19_27 RBL[27] RWL[19] MID_19_27 GND sg13_lv_nmos W=0.3u L=0.13u
MMW_19_28 WBL[28] WWL[19] SN_19_28 GND sg13_hv_nmos W=0.15u L=0.45u
MMS_19_28 MID_19_28 SN_19_28 GND GND sg13_lv_nmos W=0.3u L=0.13u
MMR_19_28 RBL[28] RWL[19] MID_19_28 GND sg13_lv_nmos W=0.3u L=0.13u
MMW_19_29 WBL[29] WWL[19] SN_19_29 GND sg13_hv_nmos W=0.15u L=0.45u
MMS_19_29 MID_19_29 SN_19_29 GND GND sg13_lv_nmos W=0.3u L=0.13u
MMR_19_29 RBL[29] RWL[19] MID_19_29 GND sg13_lv_nmos W=0.3u L=0.13u
MMW_19_30 WBL[30] WWL[19] SN_19_30 GND sg13_hv_nmos W=0.15u L=0.45u
MMS_19_30 MID_19_30 SN_19_30 GND GND sg13_lv_nmos W=0.3u L=0.13u
MMR_19_30 RBL[30] RWL[19] MID_19_30 GND sg13_lv_nmos W=0.3u L=0.13u
MMW_19_31 WBL[31] WWL[19] SN_19_31 GND sg13_hv_nmos W=0.15u L=0.45u
MMS_19_31 MID_19_31 SN_19_31 GND GND sg13_lv_nmos W=0.3u L=0.13u
MMR_19_31 RBL[31] RWL[19] MID_19_31 GND sg13_lv_nmos W=0.3u L=0.13u
MMW_19_32 WBL[32] WWL[19] SN_19_32 GND sg13_hv_nmos W=0.15u L=0.45u
MMS_19_32 MID_19_32 SN_19_32 GND GND sg13_lv_nmos W=0.3u L=0.13u
MMR_19_32 RBL[32] RWL[19] MID_19_32 GND sg13_lv_nmos W=0.3u L=0.13u
MMW_19_33 WBL[33] WWL[19] SN_19_33 GND sg13_hv_nmos W=0.15u L=0.45u
MMS_19_33 MID_19_33 SN_19_33 GND GND sg13_lv_nmos W=0.3u L=0.13u
MMR_19_33 RBL[33] RWL[19] MID_19_33 GND sg13_lv_nmos W=0.3u L=0.13u
MMW_19_34 WBL[34] WWL[19] SN_19_34 GND sg13_hv_nmos W=0.15u L=0.45u
MMS_19_34 MID_19_34 SN_19_34 GND GND sg13_lv_nmos W=0.3u L=0.13u
MMR_19_34 RBL[34] RWL[19] MID_19_34 GND sg13_lv_nmos W=0.3u L=0.13u
MMW_19_35 WBL[35] WWL[19] SN_19_35 GND sg13_hv_nmos W=0.15u L=0.45u
MMS_19_35 MID_19_35 SN_19_35 GND GND sg13_lv_nmos W=0.3u L=0.13u
MMR_19_35 RBL[35] RWL[19] MID_19_35 GND sg13_lv_nmos W=0.3u L=0.13u
MMW_19_36 WBL[36] WWL[19] SN_19_36 GND sg13_hv_nmos W=0.15u L=0.45u
MMS_19_36 MID_19_36 SN_19_36 GND GND sg13_lv_nmos W=0.3u L=0.13u
MMR_19_36 RBL[36] RWL[19] MID_19_36 GND sg13_lv_nmos W=0.3u L=0.13u
MMW_19_37 WBL[37] WWL[19] SN_19_37 GND sg13_hv_nmos W=0.15u L=0.45u
MMS_19_37 MID_19_37 SN_19_37 GND GND sg13_lv_nmos W=0.3u L=0.13u
MMR_19_37 RBL[37] RWL[19] MID_19_37 GND sg13_lv_nmos W=0.3u L=0.13u
MMW_20_0 WBL[0] WWL[20] SN_20_0 GND sg13_hv_nmos W=0.15u L=0.45u
MMS_20_0 MID_20_0 SN_20_0 GND GND sg13_lv_nmos W=0.3u L=0.13u
MMR_20_0 RBL[0] RWL[20] MID_20_0 GND sg13_lv_nmos W=0.3u L=0.13u
MMW_20_1 WBL[1] WWL[20] SN_20_1 GND sg13_hv_nmos W=0.15u L=0.45u
MMS_20_1 MID_20_1 SN_20_1 GND GND sg13_lv_nmos W=0.3u L=0.13u
MMR_20_1 RBL[1] RWL[20] MID_20_1 GND sg13_lv_nmos W=0.3u L=0.13u
MMW_20_2 WBL[2] WWL[20] SN_20_2 GND sg13_hv_nmos W=0.15u L=0.45u
MMS_20_2 MID_20_2 SN_20_2 GND GND sg13_lv_nmos W=0.3u L=0.13u
MMR_20_2 RBL[2] RWL[20] MID_20_2 GND sg13_lv_nmos W=0.3u L=0.13u
MMW_20_3 WBL[3] WWL[20] SN_20_3 GND sg13_hv_nmos W=0.15u L=0.45u
MMS_20_3 MID_20_3 SN_20_3 GND GND sg13_lv_nmos W=0.3u L=0.13u
MMR_20_3 RBL[3] RWL[20] MID_20_3 GND sg13_lv_nmos W=0.3u L=0.13u
MMW_20_4 WBL[4] WWL[20] SN_20_4 GND sg13_hv_nmos W=0.15u L=0.45u
MMS_20_4 MID_20_4 SN_20_4 GND GND sg13_lv_nmos W=0.3u L=0.13u
MMR_20_4 RBL[4] RWL[20] MID_20_4 GND sg13_lv_nmos W=0.3u L=0.13u
MMW_20_5 WBL[5] WWL[20] SN_20_5 GND sg13_hv_nmos W=0.15u L=0.45u
MMS_20_5 MID_20_5 SN_20_5 GND GND sg13_lv_nmos W=0.3u L=0.13u
MMR_20_5 RBL[5] RWL[20] MID_20_5 GND sg13_lv_nmos W=0.3u L=0.13u
MMW_20_6 WBL[6] WWL[20] SN_20_6 GND sg13_hv_nmos W=0.15u L=0.45u
MMS_20_6 MID_20_6 SN_20_6 GND GND sg13_lv_nmos W=0.3u L=0.13u
MMR_20_6 RBL[6] RWL[20] MID_20_6 GND sg13_lv_nmos W=0.3u L=0.13u
MMW_20_7 WBL[7] WWL[20] SN_20_7 GND sg13_hv_nmos W=0.15u L=0.45u
MMS_20_7 MID_20_7 SN_20_7 GND GND sg13_lv_nmos W=0.3u L=0.13u
MMR_20_7 RBL[7] RWL[20] MID_20_7 GND sg13_lv_nmos W=0.3u L=0.13u
MMW_20_8 WBL[8] WWL[20] SN_20_8 GND sg13_hv_nmos W=0.15u L=0.45u
MMS_20_8 MID_20_8 SN_20_8 GND GND sg13_lv_nmos W=0.3u L=0.13u
MMR_20_8 RBL[8] RWL[20] MID_20_8 GND sg13_lv_nmos W=0.3u L=0.13u
MMW_20_9 WBL[9] WWL[20] SN_20_9 GND sg13_hv_nmos W=0.15u L=0.45u
MMS_20_9 MID_20_9 SN_20_9 GND GND sg13_lv_nmos W=0.3u L=0.13u
MMR_20_9 RBL[9] RWL[20] MID_20_9 GND sg13_lv_nmos W=0.3u L=0.13u
MMW_20_10 WBL[10] WWL[20] SN_20_10 GND sg13_hv_nmos W=0.15u L=0.45u
MMS_20_10 MID_20_10 SN_20_10 GND GND sg13_lv_nmos W=0.3u L=0.13u
MMR_20_10 RBL[10] RWL[20] MID_20_10 GND sg13_lv_nmos W=0.3u L=0.13u
MMW_20_11 WBL[11] WWL[20] SN_20_11 GND sg13_hv_nmos W=0.15u L=0.45u
MMS_20_11 MID_20_11 SN_20_11 GND GND sg13_lv_nmos W=0.3u L=0.13u
MMR_20_11 RBL[11] RWL[20] MID_20_11 GND sg13_lv_nmos W=0.3u L=0.13u
MMW_20_12 WBL[12] WWL[20] SN_20_12 GND sg13_hv_nmos W=0.15u L=0.45u
MMS_20_12 MID_20_12 SN_20_12 GND GND sg13_lv_nmos W=0.3u L=0.13u
MMR_20_12 RBL[12] RWL[20] MID_20_12 GND sg13_lv_nmos W=0.3u L=0.13u
MMW_20_13 WBL[13] WWL[20] SN_20_13 GND sg13_hv_nmos W=0.15u L=0.45u
MMS_20_13 MID_20_13 SN_20_13 GND GND sg13_lv_nmos W=0.3u L=0.13u
MMR_20_13 RBL[13] RWL[20] MID_20_13 GND sg13_lv_nmos W=0.3u L=0.13u
MMW_20_14 WBL[14] WWL[20] SN_20_14 GND sg13_hv_nmos W=0.15u L=0.45u
MMS_20_14 MID_20_14 SN_20_14 GND GND sg13_lv_nmos W=0.3u L=0.13u
MMR_20_14 RBL[14] RWL[20] MID_20_14 GND sg13_lv_nmos W=0.3u L=0.13u
MMW_20_15 WBL[15] WWL[20] SN_20_15 GND sg13_hv_nmos W=0.15u L=0.45u
MMS_20_15 MID_20_15 SN_20_15 GND GND sg13_lv_nmos W=0.3u L=0.13u
MMR_20_15 RBL[15] RWL[20] MID_20_15 GND sg13_lv_nmos W=0.3u L=0.13u
MMW_20_16 WBL[16] WWL[20] SN_20_16 GND sg13_hv_nmos W=0.15u L=0.45u
MMS_20_16 MID_20_16 SN_20_16 GND GND sg13_lv_nmos W=0.3u L=0.13u
MMR_20_16 RBL[16] RWL[20] MID_20_16 GND sg13_lv_nmos W=0.3u L=0.13u
MMW_20_17 WBL[17] WWL[20] SN_20_17 GND sg13_hv_nmos W=0.15u L=0.45u
MMS_20_17 MID_20_17 SN_20_17 GND GND sg13_lv_nmos W=0.3u L=0.13u
MMR_20_17 RBL[17] RWL[20] MID_20_17 GND sg13_lv_nmos W=0.3u L=0.13u
MMW_20_18 WBL[18] WWL[20] SN_20_18 GND sg13_hv_nmos W=0.15u L=0.45u
MMS_20_18 MID_20_18 SN_20_18 GND GND sg13_lv_nmos W=0.3u L=0.13u
MMR_20_18 RBL[18] RWL[20] MID_20_18 GND sg13_lv_nmos W=0.3u L=0.13u
MMW_20_19 WBL[19] WWL[20] SN_20_19 GND sg13_hv_nmos W=0.15u L=0.45u
MMS_20_19 MID_20_19 SN_20_19 GND GND sg13_lv_nmos W=0.3u L=0.13u
MMR_20_19 RBL[19] RWL[20] MID_20_19 GND sg13_lv_nmos W=0.3u L=0.13u
MMW_20_20 WBL[20] WWL[20] SN_20_20 GND sg13_hv_nmos W=0.15u L=0.45u
MMS_20_20 MID_20_20 SN_20_20 GND GND sg13_lv_nmos W=0.3u L=0.13u
MMR_20_20 RBL[20] RWL[20] MID_20_20 GND sg13_lv_nmos W=0.3u L=0.13u
MMW_20_21 WBL[21] WWL[20] SN_20_21 GND sg13_hv_nmos W=0.15u L=0.45u
MMS_20_21 MID_20_21 SN_20_21 GND GND sg13_lv_nmos W=0.3u L=0.13u
MMR_20_21 RBL[21] RWL[20] MID_20_21 GND sg13_lv_nmos W=0.3u L=0.13u
MMW_20_22 WBL[22] WWL[20] SN_20_22 GND sg13_hv_nmos W=0.15u L=0.45u
MMS_20_22 MID_20_22 SN_20_22 GND GND sg13_lv_nmos W=0.3u L=0.13u
MMR_20_22 RBL[22] RWL[20] MID_20_22 GND sg13_lv_nmos W=0.3u L=0.13u
MMW_20_23 WBL[23] WWL[20] SN_20_23 GND sg13_hv_nmos W=0.15u L=0.45u
MMS_20_23 MID_20_23 SN_20_23 GND GND sg13_lv_nmos W=0.3u L=0.13u
MMR_20_23 RBL[23] RWL[20] MID_20_23 GND sg13_lv_nmos W=0.3u L=0.13u
MMW_20_24 WBL[24] WWL[20] SN_20_24 GND sg13_hv_nmos W=0.15u L=0.45u
MMS_20_24 MID_20_24 SN_20_24 GND GND sg13_lv_nmos W=0.3u L=0.13u
MMR_20_24 RBL[24] RWL[20] MID_20_24 GND sg13_lv_nmos W=0.3u L=0.13u
MMW_20_25 WBL[25] WWL[20] SN_20_25 GND sg13_hv_nmos W=0.15u L=0.45u
MMS_20_25 MID_20_25 SN_20_25 GND GND sg13_lv_nmos W=0.3u L=0.13u
MMR_20_25 RBL[25] RWL[20] MID_20_25 GND sg13_lv_nmos W=0.3u L=0.13u
MMW_20_26 WBL[26] WWL[20] SN_20_26 GND sg13_hv_nmos W=0.15u L=0.45u
MMS_20_26 MID_20_26 SN_20_26 GND GND sg13_lv_nmos W=0.3u L=0.13u
MMR_20_26 RBL[26] RWL[20] MID_20_26 GND sg13_lv_nmos W=0.3u L=0.13u
MMW_20_27 WBL[27] WWL[20] SN_20_27 GND sg13_hv_nmos W=0.15u L=0.45u
MMS_20_27 MID_20_27 SN_20_27 GND GND sg13_lv_nmos W=0.3u L=0.13u
MMR_20_27 RBL[27] RWL[20] MID_20_27 GND sg13_lv_nmos W=0.3u L=0.13u
MMW_20_28 WBL[28] WWL[20] SN_20_28 GND sg13_hv_nmos W=0.15u L=0.45u
MMS_20_28 MID_20_28 SN_20_28 GND GND sg13_lv_nmos W=0.3u L=0.13u
MMR_20_28 RBL[28] RWL[20] MID_20_28 GND sg13_lv_nmos W=0.3u L=0.13u
MMW_20_29 WBL[29] WWL[20] SN_20_29 GND sg13_hv_nmos W=0.15u L=0.45u
MMS_20_29 MID_20_29 SN_20_29 GND GND sg13_lv_nmos W=0.3u L=0.13u
MMR_20_29 RBL[29] RWL[20] MID_20_29 GND sg13_lv_nmos W=0.3u L=0.13u
MMW_20_30 WBL[30] WWL[20] SN_20_30 GND sg13_hv_nmos W=0.15u L=0.45u
MMS_20_30 MID_20_30 SN_20_30 GND GND sg13_lv_nmos W=0.3u L=0.13u
MMR_20_30 RBL[30] RWL[20] MID_20_30 GND sg13_lv_nmos W=0.3u L=0.13u
MMW_20_31 WBL[31] WWL[20] SN_20_31 GND sg13_hv_nmos W=0.15u L=0.45u
MMS_20_31 MID_20_31 SN_20_31 GND GND sg13_lv_nmos W=0.3u L=0.13u
MMR_20_31 RBL[31] RWL[20] MID_20_31 GND sg13_lv_nmos W=0.3u L=0.13u
MMW_20_32 WBL[32] WWL[20] SN_20_32 GND sg13_hv_nmos W=0.15u L=0.45u
MMS_20_32 MID_20_32 SN_20_32 GND GND sg13_lv_nmos W=0.3u L=0.13u
MMR_20_32 RBL[32] RWL[20] MID_20_32 GND sg13_lv_nmos W=0.3u L=0.13u
MMW_20_33 WBL[33] WWL[20] SN_20_33 GND sg13_hv_nmos W=0.15u L=0.45u
MMS_20_33 MID_20_33 SN_20_33 GND GND sg13_lv_nmos W=0.3u L=0.13u
MMR_20_33 RBL[33] RWL[20] MID_20_33 GND sg13_lv_nmos W=0.3u L=0.13u
MMW_20_34 WBL[34] WWL[20] SN_20_34 GND sg13_hv_nmos W=0.15u L=0.45u
MMS_20_34 MID_20_34 SN_20_34 GND GND sg13_lv_nmos W=0.3u L=0.13u
MMR_20_34 RBL[34] RWL[20] MID_20_34 GND sg13_lv_nmos W=0.3u L=0.13u
MMW_20_35 WBL[35] WWL[20] SN_20_35 GND sg13_hv_nmos W=0.15u L=0.45u
MMS_20_35 MID_20_35 SN_20_35 GND GND sg13_lv_nmos W=0.3u L=0.13u
MMR_20_35 RBL[35] RWL[20] MID_20_35 GND sg13_lv_nmos W=0.3u L=0.13u
MMW_20_36 WBL[36] WWL[20] SN_20_36 GND sg13_hv_nmos W=0.15u L=0.45u
MMS_20_36 MID_20_36 SN_20_36 GND GND sg13_lv_nmos W=0.3u L=0.13u
MMR_20_36 RBL[36] RWL[20] MID_20_36 GND sg13_lv_nmos W=0.3u L=0.13u
MMW_20_37 WBL[37] WWL[20] SN_20_37 GND sg13_hv_nmos W=0.15u L=0.45u
MMS_20_37 MID_20_37 SN_20_37 GND GND sg13_lv_nmos W=0.3u L=0.13u
MMR_20_37 RBL[37] RWL[20] MID_20_37 GND sg13_lv_nmos W=0.3u L=0.13u
MMW_21_0 WBL[0] WWL[21] SN_21_0 GND sg13_hv_nmos W=0.15u L=0.45u
MMS_21_0 MID_21_0 SN_21_0 GND GND sg13_lv_nmos W=0.3u L=0.13u
MMR_21_0 RBL[0] RWL[21] MID_21_0 GND sg13_lv_nmos W=0.3u L=0.13u
MMW_21_1 WBL[1] WWL[21] SN_21_1 GND sg13_hv_nmos W=0.15u L=0.45u
MMS_21_1 MID_21_1 SN_21_1 GND GND sg13_lv_nmos W=0.3u L=0.13u
MMR_21_1 RBL[1] RWL[21] MID_21_1 GND sg13_lv_nmos W=0.3u L=0.13u
MMW_21_2 WBL[2] WWL[21] SN_21_2 GND sg13_hv_nmos W=0.15u L=0.45u
MMS_21_2 MID_21_2 SN_21_2 GND GND sg13_lv_nmos W=0.3u L=0.13u
MMR_21_2 RBL[2] RWL[21] MID_21_2 GND sg13_lv_nmos W=0.3u L=0.13u
MMW_21_3 WBL[3] WWL[21] SN_21_3 GND sg13_hv_nmos W=0.15u L=0.45u
MMS_21_3 MID_21_3 SN_21_3 GND GND sg13_lv_nmos W=0.3u L=0.13u
MMR_21_3 RBL[3] RWL[21] MID_21_3 GND sg13_lv_nmos W=0.3u L=0.13u
MMW_21_4 WBL[4] WWL[21] SN_21_4 GND sg13_hv_nmos W=0.15u L=0.45u
MMS_21_4 MID_21_4 SN_21_4 GND GND sg13_lv_nmos W=0.3u L=0.13u
MMR_21_4 RBL[4] RWL[21] MID_21_4 GND sg13_lv_nmos W=0.3u L=0.13u
MMW_21_5 WBL[5] WWL[21] SN_21_5 GND sg13_hv_nmos W=0.15u L=0.45u
MMS_21_5 MID_21_5 SN_21_5 GND GND sg13_lv_nmos W=0.3u L=0.13u
MMR_21_5 RBL[5] RWL[21] MID_21_5 GND sg13_lv_nmos W=0.3u L=0.13u
MMW_21_6 WBL[6] WWL[21] SN_21_6 GND sg13_hv_nmos W=0.15u L=0.45u
MMS_21_6 MID_21_6 SN_21_6 GND GND sg13_lv_nmos W=0.3u L=0.13u
MMR_21_6 RBL[6] RWL[21] MID_21_6 GND sg13_lv_nmos W=0.3u L=0.13u
MMW_21_7 WBL[7] WWL[21] SN_21_7 GND sg13_hv_nmos W=0.15u L=0.45u
MMS_21_7 MID_21_7 SN_21_7 GND GND sg13_lv_nmos W=0.3u L=0.13u
MMR_21_7 RBL[7] RWL[21] MID_21_7 GND sg13_lv_nmos W=0.3u L=0.13u
MMW_21_8 WBL[8] WWL[21] SN_21_8 GND sg13_hv_nmos W=0.15u L=0.45u
MMS_21_8 MID_21_8 SN_21_8 GND GND sg13_lv_nmos W=0.3u L=0.13u
MMR_21_8 RBL[8] RWL[21] MID_21_8 GND sg13_lv_nmos W=0.3u L=0.13u
MMW_21_9 WBL[9] WWL[21] SN_21_9 GND sg13_hv_nmos W=0.15u L=0.45u
MMS_21_9 MID_21_9 SN_21_9 GND GND sg13_lv_nmos W=0.3u L=0.13u
MMR_21_9 RBL[9] RWL[21] MID_21_9 GND sg13_lv_nmos W=0.3u L=0.13u
MMW_21_10 WBL[10] WWL[21] SN_21_10 GND sg13_hv_nmos W=0.15u L=0.45u
MMS_21_10 MID_21_10 SN_21_10 GND GND sg13_lv_nmos W=0.3u L=0.13u
MMR_21_10 RBL[10] RWL[21] MID_21_10 GND sg13_lv_nmos W=0.3u L=0.13u
MMW_21_11 WBL[11] WWL[21] SN_21_11 GND sg13_hv_nmos W=0.15u L=0.45u
MMS_21_11 MID_21_11 SN_21_11 GND GND sg13_lv_nmos W=0.3u L=0.13u
MMR_21_11 RBL[11] RWL[21] MID_21_11 GND sg13_lv_nmos W=0.3u L=0.13u
MMW_21_12 WBL[12] WWL[21] SN_21_12 GND sg13_hv_nmos W=0.15u L=0.45u
MMS_21_12 MID_21_12 SN_21_12 GND GND sg13_lv_nmos W=0.3u L=0.13u
MMR_21_12 RBL[12] RWL[21] MID_21_12 GND sg13_lv_nmos W=0.3u L=0.13u
MMW_21_13 WBL[13] WWL[21] SN_21_13 GND sg13_hv_nmos W=0.15u L=0.45u
MMS_21_13 MID_21_13 SN_21_13 GND GND sg13_lv_nmos W=0.3u L=0.13u
MMR_21_13 RBL[13] RWL[21] MID_21_13 GND sg13_lv_nmos W=0.3u L=0.13u
MMW_21_14 WBL[14] WWL[21] SN_21_14 GND sg13_hv_nmos W=0.15u L=0.45u
MMS_21_14 MID_21_14 SN_21_14 GND GND sg13_lv_nmos W=0.3u L=0.13u
MMR_21_14 RBL[14] RWL[21] MID_21_14 GND sg13_lv_nmos W=0.3u L=0.13u
MMW_21_15 WBL[15] WWL[21] SN_21_15 GND sg13_hv_nmos W=0.15u L=0.45u
MMS_21_15 MID_21_15 SN_21_15 GND GND sg13_lv_nmos W=0.3u L=0.13u
MMR_21_15 RBL[15] RWL[21] MID_21_15 GND sg13_lv_nmos W=0.3u L=0.13u
MMW_21_16 WBL[16] WWL[21] SN_21_16 GND sg13_hv_nmos W=0.15u L=0.45u
MMS_21_16 MID_21_16 SN_21_16 GND GND sg13_lv_nmos W=0.3u L=0.13u
MMR_21_16 RBL[16] RWL[21] MID_21_16 GND sg13_lv_nmos W=0.3u L=0.13u
MMW_21_17 WBL[17] WWL[21] SN_21_17 GND sg13_hv_nmos W=0.15u L=0.45u
MMS_21_17 MID_21_17 SN_21_17 GND GND sg13_lv_nmos W=0.3u L=0.13u
MMR_21_17 RBL[17] RWL[21] MID_21_17 GND sg13_lv_nmos W=0.3u L=0.13u
MMW_21_18 WBL[18] WWL[21] SN_21_18 GND sg13_hv_nmos W=0.15u L=0.45u
MMS_21_18 MID_21_18 SN_21_18 GND GND sg13_lv_nmos W=0.3u L=0.13u
MMR_21_18 RBL[18] RWL[21] MID_21_18 GND sg13_lv_nmos W=0.3u L=0.13u
MMW_21_19 WBL[19] WWL[21] SN_21_19 GND sg13_hv_nmos W=0.15u L=0.45u
MMS_21_19 MID_21_19 SN_21_19 GND GND sg13_lv_nmos W=0.3u L=0.13u
MMR_21_19 RBL[19] RWL[21] MID_21_19 GND sg13_lv_nmos W=0.3u L=0.13u
MMW_21_20 WBL[20] WWL[21] SN_21_20 GND sg13_hv_nmos W=0.15u L=0.45u
MMS_21_20 MID_21_20 SN_21_20 GND GND sg13_lv_nmos W=0.3u L=0.13u
MMR_21_20 RBL[20] RWL[21] MID_21_20 GND sg13_lv_nmos W=0.3u L=0.13u
MMW_21_21 WBL[21] WWL[21] SN_21_21 GND sg13_hv_nmos W=0.15u L=0.45u
MMS_21_21 MID_21_21 SN_21_21 GND GND sg13_lv_nmos W=0.3u L=0.13u
MMR_21_21 RBL[21] RWL[21] MID_21_21 GND sg13_lv_nmos W=0.3u L=0.13u
MMW_21_22 WBL[22] WWL[21] SN_21_22 GND sg13_hv_nmos W=0.15u L=0.45u
MMS_21_22 MID_21_22 SN_21_22 GND GND sg13_lv_nmos W=0.3u L=0.13u
MMR_21_22 RBL[22] RWL[21] MID_21_22 GND sg13_lv_nmos W=0.3u L=0.13u
MMW_21_23 WBL[23] WWL[21] SN_21_23 GND sg13_hv_nmos W=0.15u L=0.45u
MMS_21_23 MID_21_23 SN_21_23 GND GND sg13_lv_nmos W=0.3u L=0.13u
MMR_21_23 RBL[23] RWL[21] MID_21_23 GND sg13_lv_nmos W=0.3u L=0.13u
MMW_21_24 WBL[24] WWL[21] SN_21_24 GND sg13_hv_nmos W=0.15u L=0.45u
MMS_21_24 MID_21_24 SN_21_24 GND GND sg13_lv_nmos W=0.3u L=0.13u
MMR_21_24 RBL[24] RWL[21] MID_21_24 GND sg13_lv_nmos W=0.3u L=0.13u
MMW_21_25 WBL[25] WWL[21] SN_21_25 GND sg13_hv_nmos W=0.15u L=0.45u
MMS_21_25 MID_21_25 SN_21_25 GND GND sg13_lv_nmos W=0.3u L=0.13u
MMR_21_25 RBL[25] RWL[21] MID_21_25 GND sg13_lv_nmos W=0.3u L=0.13u
MMW_21_26 WBL[26] WWL[21] SN_21_26 GND sg13_hv_nmos W=0.15u L=0.45u
MMS_21_26 MID_21_26 SN_21_26 GND GND sg13_lv_nmos W=0.3u L=0.13u
MMR_21_26 RBL[26] RWL[21] MID_21_26 GND sg13_lv_nmos W=0.3u L=0.13u
MMW_21_27 WBL[27] WWL[21] SN_21_27 GND sg13_hv_nmos W=0.15u L=0.45u
MMS_21_27 MID_21_27 SN_21_27 GND GND sg13_lv_nmos W=0.3u L=0.13u
MMR_21_27 RBL[27] RWL[21] MID_21_27 GND sg13_lv_nmos W=0.3u L=0.13u
MMW_21_28 WBL[28] WWL[21] SN_21_28 GND sg13_hv_nmos W=0.15u L=0.45u
MMS_21_28 MID_21_28 SN_21_28 GND GND sg13_lv_nmos W=0.3u L=0.13u
MMR_21_28 RBL[28] RWL[21] MID_21_28 GND sg13_lv_nmos W=0.3u L=0.13u
MMW_21_29 WBL[29] WWL[21] SN_21_29 GND sg13_hv_nmos W=0.15u L=0.45u
MMS_21_29 MID_21_29 SN_21_29 GND GND sg13_lv_nmos W=0.3u L=0.13u
MMR_21_29 RBL[29] RWL[21] MID_21_29 GND sg13_lv_nmos W=0.3u L=0.13u
MMW_21_30 WBL[30] WWL[21] SN_21_30 GND sg13_hv_nmos W=0.15u L=0.45u
MMS_21_30 MID_21_30 SN_21_30 GND GND sg13_lv_nmos W=0.3u L=0.13u
MMR_21_30 RBL[30] RWL[21] MID_21_30 GND sg13_lv_nmos W=0.3u L=0.13u
MMW_21_31 WBL[31] WWL[21] SN_21_31 GND sg13_hv_nmos W=0.15u L=0.45u
MMS_21_31 MID_21_31 SN_21_31 GND GND sg13_lv_nmos W=0.3u L=0.13u
MMR_21_31 RBL[31] RWL[21] MID_21_31 GND sg13_lv_nmos W=0.3u L=0.13u
MMW_21_32 WBL[32] WWL[21] SN_21_32 GND sg13_hv_nmos W=0.15u L=0.45u
MMS_21_32 MID_21_32 SN_21_32 GND GND sg13_lv_nmos W=0.3u L=0.13u
MMR_21_32 RBL[32] RWL[21] MID_21_32 GND sg13_lv_nmos W=0.3u L=0.13u
MMW_21_33 WBL[33] WWL[21] SN_21_33 GND sg13_hv_nmos W=0.15u L=0.45u
MMS_21_33 MID_21_33 SN_21_33 GND GND sg13_lv_nmos W=0.3u L=0.13u
MMR_21_33 RBL[33] RWL[21] MID_21_33 GND sg13_lv_nmos W=0.3u L=0.13u
MMW_21_34 WBL[34] WWL[21] SN_21_34 GND sg13_hv_nmos W=0.15u L=0.45u
MMS_21_34 MID_21_34 SN_21_34 GND GND sg13_lv_nmos W=0.3u L=0.13u
MMR_21_34 RBL[34] RWL[21] MID_21_34 GND sg13_lv_nmos W=0.3u L=0.13u
MMW_21_35 WBL[35] WWL[21] SN_21_35 GND sg13_hv_nmos W=0.15u L=0.45u
MMS_21_35 MID_21_35 SN_21_35 GND GND sg13_lv_nmos W=0.3u L=0.13u
MMR_21_35 RBL[35] RWL[21] MID_21_35 GND sg13_lv_nmos W=0.3u L=0.13u
MMW_21_36 WBL[36] WWL[21] SN_21_36 GND sg13_hv_nmos W=0.15u L=0.45u
MMS_21_36 MID_21_36 SN_21_36 GND GND sg13_lv_nmos W=0.3u L=0.13u
MMR_21_36 RBL[36] RWL[21] MID_21_36 GND sg13_lv_nmos W=0.3u L=0.13u
MMW_21_37 WBL[37] WWL[21] SN_21_37 GND sg13_hv_nmos W=0.15u L=0.45u
MMS_21_37 MID_21_37 SN_21_37 GND GND sg13_lv_nmos W=0.3u L=0.13u
MMR_21_37 RBL[37] RWL[21] MID_21_37 GND sg13_lv_nmos W=0.3u L=0.13u
MMW_22_0 WBL[0] WWL[22] SN_22_0 GND sg13_hv_nmos W=0.15u L=0.45u
MMS_22_0 MID_22_0 SN_22_0 GND GND sg13_lv_nmos W=0.3u L=0.13u
MMR_22_0 RBL[0] RWL[22] MID_22_0 GND sg13_lv_nmos W=0.3u L=0.13u
MMW_22_1 WBL[1] WWL[22] SN_22_1 GND sg13_hv_nmos W=0.15u L=0.45u
MMS_22_1 MID_22_1 SN_22_1 GND GND sg13_lv_nmos W=0.3u L=0.13u
MMR_22_1 RBL[1] RWL[22] MID_22_1 GND sg13_lv_nmos W=0.3u L=0.13u
MMW_22_2 WBL[2] WWL[22] SN_22_2 GND sg13_hv_nmos W=0.15u L=0.45u
MMS_22_2 MID_22_2 SN_22_2 GND GND sg13_lv_nmos W=0.3u L=0.13u
MMR_22_2 RBL[2] RWL[22] MID_22_2 GND sg13_lv_nmos W=0.3u L=0.13u
MMW_22_3 WBL[3] WWL[22] SN_22_3 GND sg13_hv_nmos W=0.15u L=0.45u
MMS_22_3 MID_22_3 SN_22_3 GND GND sg13_lv_nmos W=0.3u L=0.13u
MMR_22_3 RBL[3] RWL[22] MID_22_3 GND sg13_lv_nmos W=0.3u L=0.13u
MMW_22_4 WBL[4] WWL[22] SN_22_4 GND sg13_hv_nmos W=0.15u L=0.45u
MMS_22_4 MID_22_4 SN_22_4 GND GND sg13_lv_nmos W=0.3u L=0.13u
MMR_22_4 RBL[4] RWL[22] MID_22_4 GND sg13_lv_nmos W=0.3u L=0.13u
MMW_22_5 WBL[5] WWL[22] SN_22_5 GND sg13_hv_nmos W=0.15u L=0.45u
MMS_22_5 MID_22_5 SN_22_5 GND GND sg13_lv_nmos W=0.3u L=0.13u
MMR_22_5 RBL[5] RWL[22] MID_22_5 GND sg13_lv_nmos W=0.3u L=0.13u
MMW_22_6 WBL[6] WWL[22] SN_22_6 GND sg13_hv_nmos W=0.15u L=0.45u
MMS_22_6 MID_22_6 SN_22_6 GND GND sg13_lv_nmos W=0.3u L=0.13u
MMR_22_6 RBL[6] RWL[22] MID_22_6 GND sg13_lv_nmos W=0.3u L=0.13u
MMW_22_7 WBL[7] WWL[22] SN_22_7 GND sg13_hv_nmos W=0.15u L=0.45u
MMS_22_7 MID_22_7 SN_22_7 GND GND sg13_lv_nmos W=0.3u L=0.13u
MMR_22_7 RBL[7] RWL[22] MID_22_7 GND sg13_lv_nmos W=0.3u L=0.13u
MMW_22_8 WBL[8] WWL[22] SN_22_8 GND sg13_hv_nmos W=0.15u L=0.45u
MMS_22_8 MID_22_8 SN_22_8 GND GND sg13_lv_nmos W=0.3u L=0.13u
MMR_22_8 RBL[8] RWL[22] MID_22_8 GND sg13_lv_nmos W=0.3u L=0.13u
MMW_22_9 WBL[9] WWL[22] SN_22_9 GND sg13_hv_nmos W=0.15u L=0.45u
MMS_22_9 MID_22_9 SN_22_9 GND GND sg13_lv_nmos W=0.3u L=0.13u
MMR_22_9 RBL[9] RWL[22] MID_22_9 GND sg13_lv_nmos W=0.3u L=0.13u
MMW_22_10 WBL[10] WWL[22] SN_22_10 GND sg13_hv_nmos W=0.15u L=0.45u
MMS_22_10 MID_22_10 SN_22_10 GND GND sg13_lv_nmos W=0.3u L=0.13u
MMR_22_10 RBL[10] RWL[22] MID_22_10 GND sg13_lv_nmos W=0.3u L=0.13u
MMW_22_11 WBL[11] WWL[22] SN_22_11 GND sg13_hv_nmos W=0.15u L=0.45u
MMS_22_11 MID_22_11 SN_22_11 GND GND sg13_lv_nmos W=0.3u L=0.13u
MMR_22_11 RBL[11] RWL[22] MID_22_11 GND sg13_lv_nmos W=0.3u L=0.13u
MMW_22_12 WBL[12] WWL[22] SN_22_12 GND sg13_hv_nmos W=0.15u L=0.45u
MMS_22_12 MID_22_12 SN_22_12 GND GND sg13_lv_nmos W=0.3u L=0.13u
MMR_22_12 RBL[12] RWL[22] MID_22_12 GND sg13_lv_nmos W=0.3u L=0.13u
MMW_22_13 WBL[13] WWL[22] SN_22_13 GND sg13_hv_nmos W=0.15u L=0.45u
MMS_22_13 MID_22_13 SN_22_13 GND GND sg13_lv_nmos W=0.3u L=0.13u
MMR_22_13 RBL[13] RWL[22] MID_22_13 GND sg13_lv_nmos W=0.3u L=0.13u
MMW_22_14 WBL[14] WWL[22] SN_22_14 GND sg13_hv_nmos W=0.15u L=0.45u
MMS_22_14 MID_22_14 SN_22_14 GND GND sg13_lv_nmos W=0.3u L=0.13u
MMR_22_14 RBL[14] RWL[22] MID_22_14 GND sg13_lv_nmos W=0.3u L=0.13u
MMW_22_15 WBL[15] WWL[22] SN_22_15 GND sg13_hv_nmos W=0.15u L=0.45u
MMS_22_15 MID_22_15 SN_22_15 GND GND sg13_lv_nmos W=0.3u L=0.13u
MMR_22_15 RBL[15] RWL[22] MID_22_15 GND sg13_lv_nmos W=0.3u L=0.13u
MMW_22_16 WBL[16] WWL[22] SN_22_16 GND sg13_hv_nmos W=0.15u L=0.45u
MMS_22_16 MID_22_16 SN_22_16 GND GND sg13_lv_nmos W=0.3u L=0.13u
MMR_22_16 RBL[16] RWL[22] MID_22_16 GND sg13_lv_nmos W=0.3u L=0.13u
MMW_22_17 WBL[17] WWL[22] SN_22_17 GND sg13_hv_nmos W=0.15u L=0.45u
MMS_22_17 MID_22_17 SN_22_17 GND GND sg13_lv_nmos W=0.3u L=0.13u
MMR_22_17 RBL[17] RWL[22] MID_22_17 GND sg13_lv_nmos W=0.3u L=0.13u
MMW_22_18 WBL[18] WWL[22] SN_22_18 GND sg13_hv_nmos W=0.15u L=0.45u
MMS_22_18 MID_22_18 SN_22_18 GND GND sg13_lv_nmos W=0.3u L=0.13u
MMR_22_18 RBL[18] RWL[22] MID_22_18 GND sg13_lv_nmos W=0.3u L=0.13u
MMW_22_19 WBL[19] WWL[22] SN_22_19 GND sg13_hv_nmos W=0.15u L=0.45u
MMS_22_19 MID_22_19 SN_22_19 GND GND sg13_lv_nmos W=0.3u L=0.13u
MMR_22_19 RBL[19] RWL[22] MID_22_19 GND sg13_lv_nmos W=0.3u L=0.13u
MMW_22_20 WBL[20] WWL[22] SN_22_20 GND sg13_hv_nmos W=0.15u L=0.45u
MMS_22_20 MID_22_20 SN_22_20 GND GND sg13_lv_nmos W=0.3u L=0.13u
MMR_22_20 RBL[20] RWL[22] MID_22_20 GND sg13_lv_nmos W=0.3u L=0.13u
MMW_22_21 WBL[21] WWL[22] SN_22_21 GND sg13_hv_nmos W=0.15u L=0.45u
MMS_22_21 MID_22_21 SN_22_21 GND GND sg13_lv_nmos W=0.3u L=0.13u
MMR_22_21 RBL[21] RWL[22] MID_22_21 GND sg13_lv_nmos W=0.3u L=0.13u
MMW_22_22 WBL[22] WWL[22] SN_22_22 GND sg13_hv_nmos W=0.15u L=0.45u
MMS_22_22 MID_22_22 SN_22_22 GND GND sg13_lv_nmos W=0.3u L=0.13u
MMR_22_22 RBL[22] RWL[22] MID_22_22 GND sg13_lv_nmos W=0.3u L=0.13u
MMW_22_23 WBL[23] WWL[22] SN_22_23 GND sg13_hv_nmos W=0.15u L=0.45u
MMS_22_23 MID_22_23 SN_22_23 GND GND sg13_lv_nmos W=0.3u L=0.13u
MMR_22_23 RBL[23] RWL[22] MID_22_23 GND sg13_lv_nmos W=0.3u L=0.13u
MMW_22_24 WBL[24] WWL[22] SN_22_24 GND sg13_hv_nmos W=0.15u L=0.45u
MMS_22_24 MID_22_24 SN_22_24 GND GND sg13_lv_nmos W=0.3u L=0.13u
MMR_22_24 RBL[24] RWL[22] MID_22_24 GND sg13_lv_nmos W=0.3u L=0.13u
MMW_22_25 WBL[25] WWL[22] SN_22_25 GND sg13_hv_nmos W=0.15u L=0.45u
MMS_22_25 MID_22_25 SN_22_25 GND GND sg13_lv_nmos W=0.3u L=0.13u
MMR_22_25 RBL[25] RWL[22] MID_22_25 GND sg13_lv_nmos W=0.3u L=0.13u
MMW_22_26 WBL[26] WWL[22] SN_22_26 GND sg13_hv_nmos W=0.15u L=0.45u
MMS_22_26 MID_22_26 SN_22_26 GND GND sg13_lv_nmos W=0.3u L=0.13u
MMR_22_26 RBL[26] RWL[22] MID_22_26 GND sg13_lv_nmos W=0.3u L=0.13u
MMW_22_27 WBL[27] WWL[22] SN_22_27 GND sg13_hv_nmos W=0.15u L=0.45u
MMS_22_27 MID_22_27 SN_22_27 GND GND sg13_lv_nmos W=0.3u L=0.13u
MMR_22_27 RBL[27] RWL[22] MID_22_27 GND sg13_lv_nmos W=0.3u L=0.13u
MMW_22_28 WBL[28] WWL[22] SN_22_28 GND sg13_hv_nmos W=0.15u L=0.45u
MMS_22_28 MID_22_28 SN_22_28 GND GND sg13_lv_nmos W=0.3u L=0.13u
MMR_22_28 RBL[28] RWL[22] MID_22_28 GND sg13_lv_nmos W=0.3u L=0.13u
MMW_22_29 WBL[29] WWL[22] SN_22_29 GND sg13_hv_nmos W=0.15u L=0.45u
MMS_22_29 MID_22_29 SN_22_29 GND GND sg13_lv_nmos W=0.3u L=0.13u
MMR_22_29 RBL[29] RWL[22] MID_22_29 GND sg13_lv_nmos W=0.3u L=0.13u
MMW_22_30 WBL[30] WWL[22] SN_22_30 GND sg13_hv_nmos W=0.15u L=0.45u
MMS_22_30 MID_22_30 SN_22_30 GND GND sg13_lv_nmos W=0.3u L=0.13u
MMR_22_30 RBL[30] RWL[22] MID_22_30 GND sg13_lv_nmos W=0.3u L=0.13u
MMW_22_31 WBL[31] WWL[22] SN_22_31 GND sg13_hv_nmos W=0.15u L=0.45u
MMS_22_31 MID_22_31 SN_22_31 GND GND sg13_lv_nmos W=0.3u L=0.13u
MMR_22_31 RBL[31] RWL[22] MID_22_31 GND sg13_lv_nmos W=0.3u L=0.13u
MMW_22_32 WBL[32] WWL[22] SN_22_32 GND sg13_hv_nmos W=0.15u L=0.45u
MMS_22_32 MID_22_32 SN_22_32 GND GND sg13_lv_nmos W=0.3u L=0.13u
MMR_22_32 RBL[32] RWL[22] MID_22_32 GND sg13_lv_nmos W=0.3u L=0.13u
MMW_22_33 WBL[33] WWL[22] SN_22_33 GND sg13_hv_nmos W=0.15u L=0.45u
MMS_22_33 MID_22_33 SN_22_33 GND GND sg13_lv_nmos W=0.3u L=0.13u
MMR_22_33 RBL[33] RWL[22] MID_22_33 GND sg13_lv_nmos W=0.3u L=0.13u
MMW_22_34 WBL[34] WWL[22] SN_22_34 GND sg13_hv_nmos W=0.15u L=0.45u
MMS_22_34 MID_22_34 SN_22_34 GND GND sg13_lv_nmos W=0.3u L=0.13u
MMR_22_34 RBL[34] RWL[22] MID_22_34 GND sg13_lv_nmos W=0.3u L=0.13u
MMW_22_35 WBL[35] WWL[22] SN_22_35 GND sg13_hv_nmos W=0.15u L=0.45u
MMS_22_35 MID_22_35 SN_22_35 GND GND sg13_lv_nmos W=0.3u L=0.13u
MMR_22_35 RBL[35] RWL[22] MID_22_35 GND sg13_lv_nmos W=0.3u L=0.13u
MMW_22_36 WBL[36] WWL[22] SN_22_36 GND sg13_hv_nmos W=0.15u L=0.45u
MMS_22_36 MID_22_36 SN_22_36 GND GND sg13_lv_nmos W=0.3u L=0.13u
MMR_22_36 RBL[36] RWL[22] MID_22_36 GND sg13_lv_nmos W=0.3u L=0.13u
MMW_22_37 WBL[37] WWL[22] SN_22_37 GND sg13_hv_nmos W=0.15u L=0.45u
MMS_22_37 MID_22_37 SN_22_37 GND GND sg13_lv_nmos W=0.3u L=0.13u
MMR_22_37 RBL[37] RWL[22] MID_22_37 GND sg13_lv_nmos W=0.3u L=0.13u
MMW_23_0 WBL[0] WWL[23] SN_23_0 GND sg13_hv_nmos W=0.15u L=0.45u
MMS_23_0 MID_23_0 SN_23_0 GND GND sg13_lv_nmos W=0.3u L=0.13u
MMR_23_0 RBL[0] RWL[23] MID_23_0 GND sg13_lv_nmos W=0.3u L=0.13u
MMW_23_1 WBL[1] WWL[23] SN_23_1 GND sg13_hv_nmos W=0.15u L=0.45u
MMS_23_1 MID_23_1 SN_23_1 GND GND sg13_lv_nmos W=0.3u L=0.13u
MMR_23_1 RBL[1] RWL[23] MID_23_1 GND sg13_lv_nmos W=0.3u L=0.13u
MMW_23_2 WBL[2] WWL[23] SN_23_2 GND sg13_hv_nmos W=0.15u L=0.45u
MMS_23_2 MID_23_2 SN_23_2 GND GND sg13_lv_nmos W=0.3u L=0.13u
MMR_23_2 RBL[2] RWL[23] MID_23_2 GND sg13_lv_nmos W=0.3u L=0.13u
MMW_23_3 WBL[3] WWL[23] SN_23_3 GND sg13_hv_nmos W=0.15u L=0.45u
MMS_23_3 MID_23_3 SN_23_3 GND GND sg13_lv_nmos W=0.3u L=0.13u
MMR_23_3 RBL[3] RWL[23] MID_23_3 GND sg13_lv_nmos W=0.3u L=0.13u
MMW_23_4 WBL[4] WWL[23] SN_23_4 GND sg13_hv_nmos W=0.15u L=0.45u
MMS_23_4 MID_23_4 SN_23_4 GND GND sg13_lv_nmos W=0.3u L=0.13u
MMR_23_4 RBL[4] RWL[23] MID_23_4 GND sg13_lv_nmos W=0.3u L=0.13u
MMW_23_5 WBL[5] WWL[23] SN_23_5 GND sg13_hv_nmos W=0.15u L=0.45u
MMS_23_5 MID_23_5 SN_23_5 GND GND sg13_lv_nmos W=0.3u L=0.13u
MMR_23_5 RBL[5] RWL[23] MID_23_5 GND sg13_lv_nmos W=0.3u L=0.13u
MMW_23_6 WBL[6] WWL[23] SN_23_6 GND sg13_hv_nmos W=0.15u L=0.45u
MMS_23_6 MID_23_6 SN_23_6 GND GND sg13_lv_nmos W=0.3u L=0.13u
MMR_23_6 RBL[6] RWL[23] MID_23_6 GND sg13_lv_nmos W=0.3u L=0.13u
MMW_23_7 WBL[7] WWL[23] SN_23_7 GND sg13_hv_nmos W=0.15u L=0.45u
MMS_23_7 MID_23_7 SN_23_7 GND GND sg13_lv_nmos W=0.3u L=0.13u
MMR_23_7 RBL[7] RWL[23] MID_23_7 GND sg13_lv_nmos W=0.3u L=0.13u
MMW_23_8 WBL[8] WWL[23] SN_23_8 GND sg13_hv_nmos W=0.15u L=0.45u
MMS_23_8 MID_23_8 SN_23_8 GND GND sg13_lv_nmos W=0.3u L=0.13u
MMR_23_8 RBL[8] RWL[23] MID_23_8 GND sg13_lv_nmos W=0.3u L=0.13u
MMW_23_9 WBL[9] WWL[23] SN_23_9 GND sg13_hv_nmos W=0.15u L=0.45u
MMS_23_9 MID_23_9 SN_23_9 GND GND sg13_lv_nmos W=0.3u L=0.13u
MMR_23_9 RBL[9] RWL[23] MID_23_9 GND sg13_lv_nmos W=0.3u L=0.13u
MMW_23_10 WBL[10] WWL[23] SN_23_10 GND sg13_hv_nmos W=0.15u L=0.45u
MMS_23_10 MID_23_10 SN_23_10 GND GND sg13_lv_nmos W=0.3u L=0.13u
MMR_23_10 RBL[10] RWL[23] MID_23_10 GND sg13_lv_nmos W=0.3u L=0.13u
MMW_23_11 WBL[11] WWL[23] SN_23_11 GND sg13_hv_nmos W=0.15u L=0.45u
MMS_23_11 MID_23_11 SN_23_11 GND GND sg13_lv_nmos W=0.3u L=0.13u
MMR_23_11 RBL[11] RWL[23] MID_23_11 GND sg13_lv_nmos W=0.3u L=0.13u
MMW_23_12 WBL[12] WWL[23] SN_23_12 GND sg13_hv_nmos W=0.15u L=0.45u
MMS_23_12 MID_23_12 SN_23_12 GND GND sg13_lv_nmos W=0.3u L=0.13u
MMR_23_12 RBL[12] RWL[23] MID_23_12 GND sg13_lv_nmos W=0.3u L=0.13u
MMW_23_13 WBL[13] WWL[23] SN_23_13 GND sg13_hv_nmos W=0.15u L=0.45u
MMS_23_13 MID_23_13 SN_23_13 GND GND sg13_lv_nmos W=0.3u L=0.13u
MMR_23_13 RBL[13] RWL[23] MID_23_13 GND sg13_lv_nmos W=0.3u L=0.13u
MMW_23_14 WBL[14] WWL[23] SN_23_14 GND sg13_hv_nmos W=0.15u L=0.45u
MMS_23_14 MID_23_14 SN_23_14 GND GND sg13_lv_nmos W=0.3u L=0.13u
MMR_23_14 RBL[14] RWL[23] MID_23_14 GND sg13_lv_nmos W=0.3u L=0.13u
MMW_23_15 WBL[15] WWL[23] SN_23_15 GND sg13_hv_nmos W=0.15u L=0.45u
MMS_23_15 MID_23_15 SN_23_15 GND GND sg13_lv_nmos W=0.3u L=0.13u
MMR_23_15 RBL[15] RWL[23] MID_23_15 GND sg13_lv_nmos W=0.3u L=0.13u
MMW_23_16 WBL[16] WWL[23] SN_23_16 GND sg13_hv_nmos W=0.15u L=0.45u
MMS_23_16 MID_23_16 SN_23_16 GND GND sg13_lv_nmos W=0.3u L=0.13u
MMR_23_16 RBL[16] RWL[23] MID_23_16 GND sg13_lv_nmos W=0.3u L=0.13u
MMW_23_17 WBL[17] WWL[23] SN_23_17 GND sg13_hv_nmos W=0.15u L=0.45u
MMS_23_17 MID_23_17 SN_23_17 GND GND sg13_lv_nmos W=0.3u L=0.13u
MMR_23_17 RBL[17] RWL[23] MID_23_17 GND sg13_lv_nmos W=0.3u L=0.13u
MMW_23_18 WBL[18] WWL[23] SN_23_18 GND sg13_hv_nmos W=0.15u L=0.45u
MMS_23_18 MID_23_18 SN_23_18 GND GND sg13_lv_nmos W=0.3u L=0.13u
MMR_23_18 RBL[18] RWL[23] MID_23_18 GND sg13_lv_nmos W=0.3u L=0.13u
MMW_23_19 WBL[19] WWL[23] SN_23_19 GND sg13_hv_nmos W=0.15u L=0.45u
MMS_23_19 MID_23_19 SN_23_19 GND GND sg13_lv_nmos W=0.3u L=0.13u
MMR_23_19 RBL[19] RWL[23] MID_23_19 GND sg13_lv_nmos W=0.3u L=0.13u
MMW_23_20 WBL[20] WWL[23] SN_23_20 GND sg13_hv_nmos W=0.15u L=0.45u
MMS_23_20 MID_23_20 SN_23_20 GND GND sg13_lv_nmos W=0.3u L=0.13u
MMR_23_20 RBL[20] RWL[23] MID_23_20 GND sg13_lv_nmos W=0.3u L=0.13u
MMW_23_21 WBL[21] WWL[23] SN_23_21 GND sg13_hv_nmos W=0.15u L=0.45u
MMS_23_21 MID_23_21 SN_23_21 GND GND sg13_lv_nmos W=0.3u L=0.13u
MMR_23_21 RBL[21] RWL[23] MID_23_21 GND sg13_lv_nmos W=0.3u L=0.13u
MMW_23_22 WBL[22] WWL[23] SN_23_22 GND sg13_hv_nmos W=0.15u L=0.45u
MMS_23_22 MID_23_22 SN_23_22 GND GND sg13_lv_nmos W=0.3u L=0.13u
MMR_23_22 RBL[22] RWL[23] MID_23_22 GND sg13_lv_nmos W=0.3u L=0.13u
MMW_23_23 WBL[23] WWL[23] SN_23_23 GND sg13_hv_nmos W=0.15u L=0.45u
MMS_23_23 MID_23_23 SN_23_23 GND GND sg13_lv_nmos W=0.3u L=0.13u
MMR_23_23 RBL[23] RWL[23] MID_23_23 GND sg13_lv_nmos W=0.3u L=0.13u
MMW_23_24 WBL[24] WWL[23] SN_23_24 GND sg13_hv_nmos W=0.15u L=0.45u
MMS_23_24 MID_23_24 SN_23_24 GND GND sg13_lv_nmos W=0.3u L=0.13u
MMR_23_24 RBL[24] RWL[23] MID_23_24 GND sg13_lv_nmos W=0.3u L=0.13u
MMW_23_25 WBL[25] WWL[23] SN_23_25 GND sg13_hv_nmos W=0.15u L=0.45u
MMS_23_25 MID_23_25 SN_23_25 GND GND sg13_lv_nmos W=0.3u L=0.13u
MMR_23_25 RBL[25] RWL[23] MID_23_25 GND sg13_lv_nmos W=0.3u L=0.13u
MMW_23_26 WBL[26] WWL[23] SN_23_26 GND sg13_hv_nmos W=0.15u L=0.45u
MMS_23_26 MID_23_26 SN_23_26 GND GND sg13_lv_nmos W=0.3u L=0.13u
MMR_23_26 RBL[26] RWL[23] MID_23_26 GND sg13_lv_nmos W=0.3u L=0.13u
MMW_23_27 WBL[27] WWL[23] SN_23_27 GND sg13_hv_nmos W=0.15u L=0.45u
MMS_23_27 MID_23_27 SN_23_27 GND GND sg13_lv_nmos W=0.3u L=0.13u
MMR_23_27 RBL[27] RWL[23] MID_23_27 GND sg13_lv_nmos W=0.3u L=0.13u
MMW_23_28 WBL[28] WWL[23] SN_23_28 GND sg13_hv_nmos W=0.15u L=0.45u
MMS_23_28 MID_23_28 SN_23_28 GND GND sg13_lv_nmos W=0.3u L=0.13u
MMR_23_28 RBL[28] RWL[23] MID_23_28 GND sg13_lv_nmos W=0.3u L=0.13u
MMW_23_29 WBL[29] WWL[23] SN_23_29 GND sg13_hv_nmos W=0.15u L=0.45u
MMS_23_29 MID_23_29 SN_23_29 GND GND sg13_lv_nmos W=0.3u L=0.13u
MMR_23_29 RBL[29] RWL[23] MID_23_29 GND sg13_lv_nmos W=0.3u L=0.13u
MMW_23_30 WBL[30] WWL[23] SN_23_30 GND sg13_hv_nmos W=0.15u L=0.45u
MMS_23_30 MID_23_30 SN_23_30 GND GND sg13_lv_nmos W=0.3u L=0.13u
MMR_23_30 RBL[30] RWL[23] MID_23_30 GND sg13_lv_nmos W=0.3u L=0.13u
MMW_23_31 WBL[31] WWL[23] SN_23_31 GND sg13_hv_nmos W=0.15u L=0.45u
MMS_23_31 MID_23_31 SN_23_31 GND GND sg13_lv_nmos W=0.3u L=0.13u
MMR_23_31 RBL[31] RWL[23] MID_23_31 GND sg13_lv_nmos W=0.3u L=0.13u
MMW_23_32 WBL[32] WWL[23] SN_23_32 GND sg13_hv_nmos W=0.15u L=0.45u
MMS_23_32 MID_23_32 SN_23_32 GND GND sg13_lv_nmos W=0.3u L=0.13u
MMR_23_32 RBL[32] RWL[23] MID_23_32 GND sg13_lv_nmos W=0.3u L=0.13u
MMW_23_33 WBL[33] WWL[23] SN_23_33 GND sg13_hv_nmos W=0.15u L=0.45u
MMS_23_33 MID_23_33 SN_23_33 GND GND sg13_lv_nmos W=0.3u L=0.13u
MMR_23_33 RBL[33] RWL[23] MID_23_33 GND sg13_lv_nmos W=0.3u L=0.13u
MMW_23_34 WBL[34] WWL[23] SN_23_34 GND sg13_hv_nmos W=0.15u L=0.45u
MMS_23_34 MID_23_34 SN_23_34 GND GND sg13_lv_nmos W=0.3u L=0.13u
MMR_23_34 RBL[34] RWL[23] MID_23_34 GND sg13_lv_nmos W=0.3u L=0.13u
MMW_23_35 WBL[35] WWL[23] SN_23_35 GND sg13_hv_nmos W=0.15u L=0.45u
MMS_23_35 MID_23_35 SN_23_35 GND GND sg13_lv_nmos W=0.3u L=0.13u
MMR_23_35 RBL[35] RWL[23] MID_23_35 GND sg13_lv_nmos W=0.3u L=0.13u
MMW_23_36 WBL[36] WWL[23] SN_23_36 GND sg13_hv_nmos W=0.15u L=0.45u
MMS_23_36 MID_23_36 SN_23_36 GND GND sg13_lv_nmos W=0.3u L=0.13u
MMR_23_36 RBL[36] RWL[23] MID_23_36 GND sg13_lv_nmos W=0.3u L=0.13u
MMW_23_37 WBL[37] WWL[23] SN_23_37 GND sg13_hv_nmos W=0.15u L=0.45u
MMS_23_37 MID_23_37 SN_23_37 GND GND sg13_lv_nmos W=0.3u L=0.13u
MMR_23_37 RBL[37] RWL[23] MID_23_37 GND sg13_lv_nmos W=0.3u L=0.13u
MMW_24_0 WBL[0] WWL[24] SN_24_0 GND sg13_hv_nmos W=0.15u L=0.45u
MMS_24_0 MID_24_0 SN_24_0 GND GND sg13_lv_nmos W=0.3u L=0.13u
MMR_24_0 RBL[0] RWL[24] MID_24_0 GND sg13_lv_nmos W=0.3u L=0.13u
MMW_24_1 WBL[1] WWL[24] SN_24_1 GND sg13_hv_nmos W=0.15u L=0.45u
MMS_24_1 MID_24_1 SN_24_1 GND GND sg13_lv_nmos W=0.3u L=0.13u
MMR_24_1 RBL[1] RWL[24] MID_24_1 GND sg13_lv_nmos W=0.3u L=0.13u
MMW_24_2 WBL[2] WWL[24] SN_24_2 GND sg13_hv_nmos W=0.15u L=0.45u
MMS_24_2 MID_24_2 SN_24_2 GND GND sg13_lv_nmos W=0.3u L=0.13u
MMR_24_2 RBL[2] RWL[24] MID_24_2 GND sg13_lv_nmos W=0.3u L=0.13u
MMW_24_3 WBL[3] WWL[24] SN_24_3 GND sg13_hv_nmos W=0.15u L=0.45u
MMS_24_3 MID_24_3 SN_24_3 GND GND sg13_lv_nmos W=0.3u L=0.13u
MMR_24_3 RBL[3] RWL[24] MID_24_3 GND sg13_lv_nmos W=0.3u L=0.13u
MMW_24_4 WBL[4] WWL[24] SN_24_4 GND sg13_hv_nmos W=0.15u L=0.45u
MMS_24_4 MID_24_4 SN_24_4 GND GND sg13_lv_nmos W=0.3u L=0.13u
MMR_24_4 RBL[4] RWL[24] MID_24_4 GND sg13_lv_nmos W=0.3u L=0.13u
MMW_24_5 WBL[5] WWL[24] SN_24_5 GND sg13_hv_nmos W=0.15u L=0.45u
MMS_24_5 MID_24_5 SN_24_5 GND GND sg13_lv_nmos W=0.3u L=0.13u
MMR_24_5 RBL[5] RWL[24] MID_24_5 GND sg13_lv_nmos W=0.3u L=0.13u
MMW_24_6 WBL[6] WWL[24] SN_24_6 GND sg13_hv_nmos W=0.15u L=0.45u
MMS_24_6 MID_24_6 SN_24_6 GND GND sg13_lv_nmos W=0.3u L=0.13u
MMR_24_6 RBL[6] RWL[24] MID_24_6 GND sg13_lv_nmos W=0.3u L=0.13u
MMW_24_7 WBL[7] WWL[24] SN_24_7 GND sg13_hv_nmos W=0.15u L=0.45u
MMS_24_7 MID_24_7 SN_24_7 GND GND sg13_lv_nmos W=0.3u L=0.13u
MMR_24_7 RBL[7] RWL[24] MID_24_7 GND sg13_lv_nmos W=0.3u L=0.13u
MMW_24_8 WBL[8] WWL[24] SN_24_8 GND sg13_hv_nmos W=0.15u L=0.45u
MMS_24_8 MID_24_8 SN_24_8 GND GND sg13_lv_nmos W=0.3u L=0.13u
MMR_24_8 RBL[8] RWL[24] MID_24_8 GND sg13_lv_nmos W=0.3u L=0.13u
MMW_24_9 WBL[9] WWL[24] SN_24_9 GND sg13_hv_nmos W=0.15u L=0.45u
MMS_24_9 MID_24_9 SN_24_9 GND GND sg13_lv_nmos W=0.3u L=0.13u
MMR_24_9 RBL[9] RWL[24] MID_24_9 GND sg13_lv_nmos W=0.3u L=0.13u
MMW_24_10 WBL[10] WWL[24] SN_24_10 GND sg13_hv_nmos W=0.15u L=0.45u
MMS_24_10 MID_24_10 SN_24_10 GND GND sg13_lv_nmos W=0.3u L=0.13u
MMR_24_10 RBL[10] RWL[24] MID_24_10 GND sg13_lv_nmos W=0.3u L=0.13u
MMW_24_11 WBL[11] WWL[24] SN_24_11 GND sg13_hv_nmos W=0.15u L=0.45u
MMS_24_11 MID_24_11 SN_24_11 GND GND sg13_lv_nmos W=0.3u L=0.13u
MMR_24_11 RBL[11] RWL[24] MID_24_11 GND sg13_lv_nmos W=0.3u L=0.13u
MMW_24_12 WBL[12] WWL[24] SN_24_12 GND sg13_hv_nmos W=0.15u L=0.45u
MMS_24_12 MID_24_12 SN_24_12 GND GND sg13_lv_nmos W=0.3u L=0.13u
MMR_24_12 RBL[12] RWL[24] MID_24_12 GND sg13_lv_nmos W=0.3u L=0.13u
MMW_24_13 WBL[13] WWL[24] SN_24_13 GND sg13_hv_nmos W=0.15u L=0.45u
MMS_24_13 MID_24_13 SN_24_13 GND GND sg13_lv_nmos W=0.3u L=0.13u
MMR_24_13 RBL[13] RWL[24] MID_24_13 GND sg13_lv_nmos W=0.3u L=0.13u
MMW_24_14 WBL[14] WWL[24] SN_24_14 GND sg13_hv_nmos W=0.15u L=0.45u
MMS_24_14 MID_24_14 SN_24_14 GND GND sg13_lv_nmos W=0.3u L=0.13u
MMR_24_14 RBL[14] RWL[24] MID_24_14 GND sg13_lv_nmos W=0.3u L=0.13u
MMW_24_15 WBL[15] WWL[24] SN_24_15 GND sg13_hv_nmos W=0.15u L=0.45u
MMS_24_15 MID_24_15 SN_24_15 GND GND sg13_lv_nmos W=0.3u L=0.13u
MMR_24_15 RBL[15] RWL[24] MID_24_15 GND sg13_lv_nmos W=0.3u L=0.13u
MMW_24_16 WBL[16] WWL[24] SN_24_16 GND sg13_hv_nmos W=0.15u L=0.45u
MMS_24_16 MID_24_16 SN_24_16 GND GND sg13_lv_nmos W=0.3u L=0.13u
MMR_24_16 RBL[16] RWL[24] MID_24_16 GND sg13_lv_nmos W=0.3u L=0.13u
MMW_24_17 WBL[17] WWL[24] SN_24_17 GND sg13_hv_nmos W=0.15u L=0.45u
MMS_24_17 MID_24_17 SN_24_17 GND GND sg13_lv_nmos W=0.3u L=0.13u
MMR_24_17 RBL[17] RWL[24] MID_24_17 GND sg13_lv_nmos W=0.3u L=0.13u
MMW_24_18 WBL[18] WWL[24] SN_24_18 GND sg13_hv_nmos W=0.15u L=0.45u
MMS_24_18 MID_24_18 SN_24_18 GND GND sg13_lv_nmos W=0.3u L=0.13u
MMR_24_18 RBL[18] RWL[24] MID_24_18 GND sg13_lv_nmos W=0.3u L=0.13u
MMW_24_19 WBL[19] WWL[24] SN_24_19 GND sg13_hv_nmos W=0.15u L=0.45u
MMS_24_19 MID_24_19 SN_24_19 GND GND sg13_lv_nmos W=0.3u L=0.13u
MMR_24_19 RBL[19] RWL[24] MID_24_19 GND sg13_lv_nmos W=0.3u L=0.13u
MMW_24_20 WBL[20] WWL[24] SN_24_20 GND sg13_hv_nmos W=0.15u L=0.45u
MMS_24_20 MID_24_20 SN_24_20 GND GND sg13_lv_nmos W=0.3u L=0.13u
MMR_24_20 RBL[20] RWL[24] MID_24_20 GND sg13_lv_nmos W=0.3u L=0.13u
MMW_24_21 WBL[21] WWL[24] SN_24_21 GND sg13_hv_nmos W=0.15u L=0.45u
MMS_24_21 MID_24_21 SN_24_21 GND GND sg13_lv_nmos W=0.3u L=0.13u
MMR_24_21 RBL[21] RWL[24] MID_24_21 GND sg13_lv_nmos W=0.3u L=0.13u
MMW_24_22 WBL[22] WWL[24] SN_24_22 GND sg13_hv_nmos W=0.15u L=0.45u
MMS_24_22 MID_24_22 SN_24_22 GND GND sg13_lv_nmos W=0.3u L=0.13u
MMR_24_22 RBL[22] RWL[24] MID_24_22 GND sg13_lv_nmos W=0.3u L=0.13u
MMW_24_23 WBL[23] WWL[24] SN_24_23 GND sg13_hv_nmos W=0.15u L=0.45u
MMS_24_23 MID_24_23 SN_24_23 GND GND sg13_lv_nmos W=0.3u L=0.13u
MMR_24_23 RBL[23] RWL[24] MID_24_23 GND sg13_lv_nmos W=0.3u L=0.13u
MMW_24_24 WBL[24] WWL[24] SN_24_24 GND sg13_hv_nmos W=0.15u L=0.45u
MMS_24_24 MID_24_24 SN_24_24 GND GND sg13_lv_nmos W=0.3u L=0.13u
MMR_24_24 RBL[24] RWL[24] MID_24_24 GND sg13_lv_nmos W=0.3u L=0.13u
MMW_24_25 WBL[25] WWL[24] SN_24_25 GND sg13_hv_nmos W=0.15u L=0.45u
MMS_24_25 MID_24_25 SN_24_25 GND GND sg13_lv_nmos W=0.3u L=0.13u
MMR_24_25 RBL[25] RWL[24] MID_24_25 GND sg13_lv_nmos W=0.3u L=0.13u
MMW_24_26 WBL[26] WWL[24] SN_24_26 GND sg13_hv_nmos W=0.15u L=0.45u
MMS_24_26 MID_24_26 SN_24_26 GND GND sg13_lv_nmos W=0.3u L=0.13u
MMR_24_26 RBL[26] RWL[24] MID_24_26 GND sg13_lv_nmos W=0.3u L=0.13u
MMW_24_27 WBL[27] WWL[24] SN_24_27 GND sg13_hv_nmos W=0.15u L=0.45u
MMS_24_27 MID_24_27 SN_24_27 GND GND sg13_lv_nmos W=0.3u L=0.13u
MMR_24_27 RBL[27] RWL[24] MID_24_27 GND sg13_lv_nmos W=0.3u L=0.13u
MMW_24_28 WBL[28] WWL[24] SN_24_28 GND sg13_hv_nmos W=0.15u L=0.45u
MMS_24_28 MID_24_28 SN_24_28 GND GND sg13_lv_nmos W=0.3u L=0.13u
MMR_24_28 RBL[28] RWL[24] MID_24_28 GND sg13_lv_nmos W=0.3u L=0.13u
MMW_24_29 WBL[29] WWL[24] SN_24_29 GND sg13_hv_nmos W=0.15u L=0.45u
MMS_24_29 MID_24_29 SN_24_29 GND GND sg13_lv_nmos W=0.3u L=0.13u
MMR_24_29 RBL[29] RWL[24] MID_24_29 GND sg13_lv_nmos W=0.3u L=0.13u
MMW_24_30 WBL[30] WWL[24] SN_24_30 GND sg13_hv_nmos W=0.15u L=0.45u
MMS_24_30 MID_24_30 SN_24_30 GND GND sg13_lv_nmos W=0.3u L=0.13u
MMR_24_30 RBL[30] RWL[24] MID_24_30 GND sg13_lv_nmos W=0.3u L=0.13u
MMW_24_31 WBL[31] WWL[24] SN_24_31 GND sg13_hv_nmos W=0.15u L=0.45u
MMS_24_31 MID_24_31 SN_24_31 GND GND sg13_lv_nmos W=0.3u L=0.13u
MMR_24_31 RBL[31] RWL[24] MID_24_31 GND sg13_lv_nmos W=0.3u L=0.13u
MMW_24_32 WBL[32] WWL[24] SN_24_32 GND sg13_hv_nmos W=0.15u L=0.45u
MMS_24_32 MID_24_32 SN_24_32 GND GND sg13_lv_nmos W=0.3u L=0.13u
MMR_24_32 RBL[32] RWL[24] MID_24_32 GND sg13_lv_nmos W=0.3u L=0.13u
MMW_24_33 WBL[33] WWL[24] SN_24_33 GND sg13_hv_nmos W=0.15u L=0.45u
MMS_24_33 MID_24_33 SN_24_33 GND GND sg13_lv_nmos W=0.3u L=0.13u
MMR_24_33 RBL[33] RWL[24] MID_24_33 GND sg13_lv_nmos W=0.3u L=0.13u
MMW_24_34 WBL[34] WWL[24] SN_24_34 GND sg13_hv_nmos W=0.15u L=0.45u
MMS_24_34 MID_24_34 SN_24_34 GND GND sg13_lv_nmos W=0.3u L=0.13u
MMR_24_34 RBL[34] RWL[24] MID_24_34 GND sg13_lv_nmos W=0.3u L=0.13u
MMW_24_35 WBL[35] WWL[24] SN_24_35 GND sg13_hv_nmos W=0.15u L=0.45u
MMS_24_35 MID_24_35 SN_24_35 GND GND sg13_lv_nmos W=0.3u L=0.13u
MMR_24_35 RBL[35] RWL[24] MID_24_35 GND sg13_lv_nmos W=0.3u L=0.13u
MMW_24_36 WBL[36] WWL[24] SN_24_36 GND sg13_hv_nmos W=0.15u L=0.45u
MMS_24_36 MID_24_36 SN_24_36 GND GND sg13_lv_nmos W=0.3u L=0.13u
MMR_24_36 RBL[36] RWL[24] MID_24_36 GND sg13_lv_nmos W=0.3u L=0.13u
MMW_24_37 WBL[37] WWL[24] SN_24_37 GND sg13_hv_nmos W=0.15u L=0.45u
MMS_24_37 MID_24_37 SN_24_37 GND GND sg13_lv_nmos W=0.3u L=0.13u
MMR_24_37 RBL[37] RWL[24] MID_24_37 GND sg13_lv_nmos W=0.3u L=0.13u
MMW_25_0 WBL[0] WWL[25] SN_25_0 GND sg13_hv_nmos W=0.15u L=0.45u
MMS_25_0 MID_25_0 SN_25_0 GND GND sg13_lv_nmos W=0.3u L=0.13u
MMR_25_0 RBL[0] RWL[25] MID_25_0 GND sg13_lv_nmos W=0.3u L=0.13u
MMW_25_1 WBL[1] WWL[25] SN_25_1 GND sg13_hv_nmos W=0.15u L=0.45u
MMS_25_1 MID_25_1 SN_25_1 GND GND sg13_lv_nmos W=0.3u L=0.13u
MMR_25_1 RBL[1] RWL[25] MID_25_1 GND sg13_lv_nmos W=0.3u L=0.13u
MMW_25_2 WBL[2] WWL[25] SN_25_2 GND sg13_hv_nmos W=0.15u L=0.45u
MMS_25_2 MID_25_2 SN_25_2 GND GND sg13_lv_nmos W=0.3u L=0.13u
MMR_25_2 RBL[2] RWL[25] MID_25_2 GND sg13_lv_nmos W=0.3u L=0.13u
MMW_25_3 WBL[3] WWL[25] SN_25_3 GND sg13_hv_nmos W=0.15u L=0.45u
MMS_25_3 MID_25_3 SN_25_3 GND GND sg13_lv_nmos W=0.3u L=0.13u
MMR_25_3 RBL[3] RWL[25] MID_25_3 GND sg13_lv_nmos W=0.3u L=0.13u
MMW_25_4 WBL[4] WWL[25] SN_25_4 GND sg13_hv_nmos W=0.15u L=0.45u
MMS_25_4 MID_25_4 SN_25_4 GND GND sg13_lv_nmos W=0.3u L=0.13u
MMR_25_4 RBL[4] RWL[25] MID_25_4 GND sg13_lv_nmos W=0.3u L=0.13u
MMW_25_5 WBL[5] WWL[25] SN_25_5 GND sg13_hv_nmos W=0.15u L=0.45u
MMS_25_5 MID_25_5 SN_25_5 GND GND sg13_lv_nmos W=0.3u L=0.13u
MMR_25_5 RBL[5] RWL[25] MID_25_5 GND sg13_lv_nmos W=0.3u L=0.13u
MMW_25_6 WBL[6] WWL[25] SN_25_6 GND sg13_hv_nmos W=0.15u L=0.45u
MMS_25_6 MID_25_6 SN_25_6 GND GND sg13_lv_nmos W=0.3u L=0.13u
MMR_25_6 RBL[6] RWL[25] MID_25_6 GND sg13_lv_nmos W=0.3u L=0.13u
MMW_25_7 WBL[7] WWL[25] SN_25_7 GND sg13_hv_nmos W=0.15u L=0.45u
MMS_25_7 MID_25_7 SN_25_7 GND GND sg13_lv_nmos W=0.3u L=0.13u
MMR_25_7 RBL[7] RWL[25] MID_25_7 GND sg13_lv_nmos W=0.3u L=0.13u
MMW_25_8 WBL[8] WWL[25] SN_25_8 GND sg13_hv_nmos W=0.15u L=0.45u
MMS_25_8 MID_25_8 SN_25_8 GND GND sg13_lv_nmos W=0.3u L=0.13u
MMR_25_8 RBL[8] RWL[25] MID_25_8 GND sg13_lv_nmos W=0.3u L=0.13u
MMW_25_9 WBL[9] WWL[25] SN_25_9 GND sg13_hv_nmos W=0.15u L=0.45u
MMS_25_9 MID_25_9 SN_25_9 GND GND sg13_lv_nmos W=0.3u L=0.13u
MMR_25_9 RBL[9] RWL[25] MID_25_9 GND sg13_lv_nmos W=0.3u L=0.13u
MMW_25_10 WBL[10] WWL[25] SN_25_10 GND sg13_hv_nmos W=0.15u L=0.45u
MMS_25_10 MID_25_10 SN_25_10 GND GND sg13_lv_nmos W=0.3u L=0.13u
MMR_25_10 RBL[10] RWL[25] MID_25_10 GND sg13_lv_nmos W=0.3u L=0.13u
MMW_25_11 WBL[11] WWL[25] SN_25_11 GND sg13_hv_nmos W=0.15u L=0.45u
MMS_25_11 MID_25_11 SN_25_11 GND GND sg13_lv_nmos W=0.3u L=0.13u
MMR_25_11 RBL[11] RWL[25] MID_25_11 GND sg13_lv_nmos W=0.3u L=0.13u
MMW_25_12 WBL[12] WWL[25] SN_25_12 GND sg13_hv_nmos W=0.15u L=0.45u
MMS_25_12 MID_25_12 SN_25_12 GND GND sg13_lv_nmos W=0.3u L=0.13u
MMR_25_12 RBL[12] RWL[25] MID_25_12 GND sg13_lv_nmos W=0.3u L=0.13u
MMW_25_13 WBL[13] WWL[25] SN_25_13 GND sg13_hv_nmos W=0.15u L=0.45u
MMS_25_13 MID_25_13 SN_25_13 GND GND sg13_lv_nmos W=0.3u L=0.13u
MMR_25_13 RBL[13] RWL[25] MID_25_13 GND sg13_lv_nmos W=0.3u L=0.13u
MMW_25_14 WBL[14] WWL[25] SN_25_14 GND sg13_hv_nmos W=0.15u L=0.45u
MMS_25_14 MID_25_14 SN_25_14 GND GND sg13_lv_nmos W=0.3u L=0.13u
MMR_25_14 RBL[14] RWL[25] MID_25_14 GND sg13_lv_nmos W=0.3u L=0.13u
MMW_25_15 WBL[15] WWL[25] SN_25_15 GND sg13_hv_nmos W=0.15u L=0.45u
MMS_25_15 MID_25_15 SN_25_15 GND GND sg13_lv_nmos W=0.3u L=0.13u
MMR_25_15 RBL[15] RWL[25] MID_25_15 GND sg13_lv_nmos W=0.3u L=0.13u
MMW_25_16 WBL[16] WWL[25] SN_25_16 GND sg13_hv_nmos W=0.15u L=0.45u
MMS_25_16 MID_25_16 SN_25_16 GND GND sg13_lv_nmos W=0.3u L=0.13u
MMR_25_16 RBL[16] RWL[25] MID_25_16 GND sg13_lv_nmos W=0.3u L=0.13u
MMW_25_17 WBL[17] WWL[25] SN_25_17 GND sg13_hv_nmos W=0.15u L=0.45u
MMS_25_17 MID_25_17 SN_25_17 GND GND sg13_lv_nmos W=0.3u L=0.13u
MMR_25_17 RBL[17] RWL[25] MID_25_17 GND sg13_lv_nmos W=0.3u L=0.13u
MMW_25_18 WBL[18] WWL[25] SN_25_18 GND sg13_hv_nmos W=0.15u L=0.45u
MMS_25_18 MID_25_18 SN_25_18 GND GND sg13_lv_nmos W=0.3u L=0.13u
MMR_25_18 RBL[18] RWL[25] MID_25_18 GND sg13_lv_nmos W=0.3u L=0.13u
MMW_25_19 WBL[19] WWL[25] SN_25_19 GND sg13_hv_nmos W=0.15u L=0.45u
MMS_25_19 MID_25_19 SN_25_19 GND GND sg13_lv_nmos W=0.3u L=0.13u
MMR_25_19 RBL[19] RWL[25] MID_25_19 GND sg13_lv_nmos W=0.3u L=0.13u
MMW_25_20 WBL[20] WWL[25] SN_25_20 GND sg13_hv_nmos W=0.15u L=0.45u
MMS_25_20 MID_25_20 SN_25_20 GND GND sg13_lv_nmos W=0.3u L=0.13u
MMR_25_20 RBL[20] RWL[25] MID_25_20 GND sg13_lv_nmos W=0.3u L=0.13u
MMW_25_21 WBL[21] WWL[25] SN_25_21 GND sg13_hv_nmos W=0.15u L=0.45u
MMS_25_21 MID_25_21 SN_25_21 GND GND sg13_lv_nmos W=0.3u L=0.13u
MMR_25_21 RBL[21] RWL[25] MID_25_21 GND sg13_lv_nmos W=0.3u L=0.13u
MMW_25_22 WBL[22] WWL[25] SN_25_22 GND sg13_hv_nmos W=0.15u L=0.45u
MMS_25_22 MID_25_22 SN_25_22 GND GND sg13_lv_nmos W=0.3u L=0.13u
MMR_25_22 RBL[22] RWL[25] MID_25_22 GND sg13_lv_nmos W=0.3u L=0.13u
MMW_25_23 WBL[23] WWL[25] SN_25_23 GND sg13_hv_nmos W=0.15u L=0.45u
MMS_25_23 MID_25_23 SN_25_23 GND GND sg13_lv_nmos W=0.3u L=0.13u
MMR_25_23 RBL[23] RWL[25] MID_25_23 GND sg13_lv_nmos W=0.3u L=0.13u
MMW_25_24 WBL[24] WWL[25] SN_25_24 GND sg13_hv_nmos W=0.15u L=0.45u
MMS_25_24 MID_25_24 SN_25_24 GND GND sg13_lv_nmos W=0.3u L=0.13u
MMR_25_24 RBL[24] RWL[25] MID_25_24 GND sg13_lv_nmos W=0.3u L=0.13u
MMW_25_25 WBL[25] WWL[25] SN_25_25 GND sg13_hv_nmos W=0.15u L=0.45u
MMS_25_25 MID_25_25 SN_25_25 GND GND sg13_lv_nmos W=0.3u L=0.13u
MMR_25_25 RBL[25] RWL[25] MID_25_25 GND sg13_lv_nmos W=0.3u L=0.13u
MMW_25_26 WBL[26] WWL[25] SN_25_26 GND sg13_hv_nmos W=0.15u L=0.45u
MMS_25_26 MID_25_26 SN_25_26 GND GND sg13_lv_nmos W=0.3u L=0.13u
MMR_25_26 RBL[26] RWL[25] MID_25_26 GND sg13_lv_nmos W=0.3u L=0.13u
MMW_25_27 WBL[27] WWL[25] SN_25_27 GND sg13_hv_nmos W=0.15u L=0.45u
MMS_25_27 MID_25_27 SN_25_27 GND GND sg13_lv_nmos W=0.3u L=0.13u
MMR_25_27 RBL[27] RWL[25] MID_25_27 GND sg13_lv_nmos W=0.3u L=0.13u
MMW_25_28 WBL[28] WWL[25] SN_25_28 GND sg13_hv_nmos W=0.15u L=0.45u
MMS_25_28 MID_25_28 SN_25_28 GND GND sg13_lv_nmos W=0.3u L=0.13u
MMR_25_28 RBL[28] RWL[25] MID_25_28 GND sg13_lv_nmos W=0.3u L=0.13u
MMW_25_29 WBL[29] WWL[25] SN_25_29 GND sg13_hv_nmos W=0.15u L=0.45u
MMS_25_29 MID_25_29 SN_25_29 GND GND sg13_lv_nmos W=0.3u L=0.13u
MMR_25_29 RBL[29] RWL[25] MID_25_29 GND sg13_lv_nmos W=0.3u L=0.13u
MMW_25_30 WBL[30] WWL[25] SN_25_30 GND sg13_hv_nmos W=0.15u L=0.45u
MMS_25_30 MID_25_30 SN_25_30 GND GND sg13_lv_nmos W=0.3u L=0.13u
MMR_25_30 RBL[30] RWL[25] MID_25_30 GND sg13_lv_nmos W=0.3u L=0.13u
MMW_25_31 WBL[31] WWL[25] SN_25_31 GND sg13_hv_nmos W=0.15u L=0.45u
MMS_25_31 MID_25_31 SN_25_31 GND GND sg13_lv_nmos W=0.3u L=0.13u
MMR_25_31 RBL[31] RWL[25] MID_25_31 GND sg13_lv_nmos W=0.3u L=0.13u
MMW_25_32 WBL[32] WWL[25] SN_25_32 GND sg13_hv_nmos W=0.15u L=0.45u
MMS_25_32 MID_25_32 SN_25_32 GND GND sg13_lv_nmos W=0.3u L=0.13u
MMR_25_32 RBL[32] RWL[25] MID_25_32 GND sg13_lv_nmos W=0.3u L=0.13u
MMW_25_33 WBL[33] WWL[25] SN_25_33 GND sg13_hv_nmos W=0.15u L=0.45u
MMS_25_33 MID_25_33 SN_25_33 GND GND sg13_lv_nmos W=0.3u L=0.13u
MMR_25_33 RBL[33] RWL[25] MID_25_33 GND sg13_lv_nmos W=0.3u L=0.13u
MMW_25_34 WBL[34] WWL[25] SN_25_34 GND sg13_hv_nmos W=0.15u L=0.45u
MMS_25_34 MID_25_34 SN_25_34 GND GND sg13_lv_nmos W=0.3u L=0.13u
MMR_25_34 RBL[34] RWL[25] MID_25_34 GND sg13_lv_nmos W=0.3u L=0.13u
MMW_25_35 WBL[35] WWL[25] SN_25_35 GND sg13_hv_nmos W=0.15u L=0.45u
MMS_25_35 MID_25_35 SN_25_35 GND GND sg13_lv_nmos W=0.3u L=0.13u
MMR_25_35 RBL[35] RWL[25] MID_25_35 GND sg13_lv_nmos W=0.3u L=0.13u
MMW_25_36 WBL[36] WWL[25] SN_25_36 GND sg13_hv_nmos W=0.15u L=0.45u
MMS_25_36 MID_25_36 SN_25_36 GND GND sg13_lv_nmos W=0.3u L=0.13u
MMR_25_36 RBL[36] RWL[25] MID_25_36 GND sg13_lv_nmos W=0.3u L=0.13u
MMW_25_37 WBL[37] WWL[25] SN_25_37 GND sg13_hv_nmos W=0.15u L=0.45u
MMS_25_37 MID_25_37 SN_25_37 GND GND sg13_lv_nmos W=0.3u L=0.13u
MMR_25_37 RBL[37] RWL[25] MID_25_37 GND sg13_lv_nmos W=0.3u L=0.13u
MMW_26_0 WBL[0] WWL[26] SN_26_0 GND sg13_hv_nmos W=0.15u L=0.45u
MMS_26_0 MID_26_0 SN_26_0 GND GND sg13_lv_nmos W=0.3u L=0.13u
MMR_26_0 RBL[0] RWL[26] MID_26_0 GND sg13_lv_nmos W=0.3u L=0.13u
MMW_26_1 WBL[1] WWL[26] SN_26_1 GND sg13_hv_nmos W=0.15u L=0.45u
MMS_26_1 MID_26_1 SN_26_1 GND GND sg13_lv_nmos W=0.3u L=0.13u
MMR_26_1 RBL[1] RWL[26] MID_26_1 GND sg13_lv_nmos W=0.3u L=0.13u
MMW_26_2 WBL[2] WWL[26] SN_26_2 GND sg13_hv_nmos W=0.15u L=0.45u
MMS_26_2 MID_26_2 SN_26_2 GND GND sg13_lv_nmos W=0.3u L=0.13u
MMR_26_2 RBL[2] RWL[26] MID_26_2 GND sg13_lv_nmos W=0.3u L=0.13u
MMW_26_3 WBL[3] WWL[26] SN_26_3 GND sg13_hv_nmos W=0.15u L=0.45u
MMS_26_3 MID_26_3 SN_26_3 GND GND sg13_lv_nmos W=0.3u L=0.13u
MMR_26_3 RBL[3] RWL[26] MID_26_3 GND sg13_lv_nmos W=0.3u L=0.13u
MMW_26_4 WBL[4] WWL[26] SN_26_4 GND sg13_hv_nmos W=0.15u L=0.45u
MMS_26_4 MID_26_4 SN_26_4 GND GND sg13_lv_nmos W=0.3u L=0.13u
MMR_26_4 RBL[4] RWL[26] MID_26_4 GND sg13_lv_nmos W=0.3u L=0.13u
MMW_26_5 WBL[5] WWL[26] SN_26_5 GND sg13_hv_nmos W=0.15u L=0.45u
MMS_26_5 MID_26_5 SN_26_5 GND GND sg13_lv_nmos W=0.3u L=0.13u
MMR_26_5 RBL[5] RWL[26] MID_26_5 GND sg13_lv_nmos W=0.3u L=0.13u
MMW_26_6 WBL[6] WWL[26] SN_26_6 GND sg13_hv_nmos W=0.15u L=0.45u
MMS_26_6 MID_26_6 SN_26_6 GND GND sg13_lv_nmos W=0.3u L=0.13u
MMR_26_6 RBL[6] RWL[26] MID_26_6 GND sg13_lv_nmos W=0.3u L=0.13u
MMW_26_7 WBL[7] WWL[26] SN_26_7 GND sg13_hv_nmos W=0.15u L=0.45u
MMS_26_7 MID_26_7 SN_26_7 GND GND sg13_lv_nmos W=0.3u L=0.13u
MMR_26_7 RBL[7] RWL[26] MID_26_7 GND sg13_lv_nmos W=0.3u L=0.13u
MMW_26_8 WBL[8] WWL[26] SN_26_8 GND sg13_hv_nmos W=0.15u L=0.45u
MMS_26_8 MID_26_8 SN_26_8 GND GND sg13_lv_nmos W=0.3u L=0.13u
MMR_26_8 RBL[8] RWL[26] MID_26_8 GND sg13_lv_nmos W=0.3u L=0.13u
MMW_26_9 WBL[9] WWL[26] SN_26_9 GND sg13_hv_nmos W=0.15u L=0.45u
MMS_26_9 MID_26_9 SN_26_9 GND GND sg13_lv_nmos W=0.3u L=0.13u
MMR_26_9 RBL[9] RWL[26] MID_26_9 GND sg13_lv_nmos W=0.3u L=0.13u
MMW_26_10 WBL[10] WWL[26] SN_26_10 GND sg13_hv_nmos W=0.15u L=0.45u
MMS_26_10 MID_26_10 SN_26_10 GND GND sg13_lv_nmos W=0.3u L=0.13u
MMR_26_10 RBL[10] RWL[26] MID_26_10 GND sg13_lv_nmos W=0.3u L=0.13u
MMW_26_11 WBL[11] WWL[26] SN_26_11 GND sg13_hv_nmos W=0.15u L=0.45u
MMS_26_11 MID_26_11 SN_26_11 GND GND sg13_lv_nmos W=0.3u L=0.13u
MMR_26_11 RBL[11] RWL[26] MID_26_11 GND sg13_lv_nmos W=0.3u L=0.13u
MMW_26_12 WBL[12] WWL[26] SN_26_12 GND sg13_hv_nmos W=0.15u L=0.45u
MMS_26_12 MID_26_12 SN_26_12 GND GND sg13_lv_nmos W=0.3u L=0.13u
MMR_26_12 RBL[12] RWL[26] MID_26_12 GND sg13_lv_nmos W=0.3u L=0.13u
MMW_26_13 WBL[13] WWL[26] SN_26_13 GND sg13_hv_nmos W=0.15u L=0.45u
MMS_26_13 MID_26_13 SN_26_13 GND GND sg13_lv_nmos W=0.3u L=0.13u
MMR_26_13 RBL[13] RWL[26] MID_26_13 GND sg13_lv_nmos W=0.3u L=0.13u
MMW_26_14 WBL[14] WWL[26] SN_26_14 GND sg13_hv_nmos W=0.15u L=0.45u
MMS_26_14 MID_26_14 SN_26_14 GND GND sg13_lv_nmos W=0.3u L=0.13u
MMR_26_14 RBL[14] RWL[26] MID_26_14 GND sg13_lv_nmos W=0.3u L=0.13u
MMW_26_15 WBL[15] WWL[26] SN_26_15 GND sg13_hv_nmos W=0.15u L=0.45u
MMS_26_15 MID_26_15 SN_26_15 GND GND sg13_lv_nmos W=0.3u L=0.13u
MMR_26_15 RBL[15] RWL[26] MID_26_15 GND sg13_lv_nmos W=0.3u L=0.13u
MMW_26_16 WBL[16] WWL[26] SN_26_16 GND sg13_hv_nmos W=0.15u L=0.45u
MMS_26_16 MID_26_16 SN_26_16 GND GND sg13_lv_nmos W=0.3u L=0.13u
MMR_26_16 RBL[16] RWL[26] MID_26_16 GND sg13_lv_nmos W=0.3u L=0.13u
MMW_26_17 WBL[17] WWL[26] SN_26_17 GND sg13_hv_nmos W=0.15u L=0.45u
MMS_26_17 MID_26_17 SN_26_17 GND GND sg13_lv_nmos W=0.3u L=0.13u
MMR_26_17 RBL[17] RWL[26] MID_26_17 GND sg13_lv_nmos W=0.3u L=0.13u
MMW_26_18 WBL[18] WWL[26] SN_26_18 GND sg13_hv_nmos W=0.15u L=0.45u
MMS_26_18 MID_26_18 SN_26_18 GND GND sg13_lv_nmos W=0.3u L=0.13u
MMR_26_18 RBL[18] RWL[26] MID_26_18 GND sg13_lv_nmos W=0.3u L=0.13u
MMW_26_19 WBL[19] WWL[26] SN_26_19 GND sg13_hv_nmos W=0.15u L=0.45u
MMS_26_19 MID_26_19 SN_26_19 GND GND sg13_lv_nmos W=0.3u L=0.13u
MMR_26_19 RBL[19] RWL[26] MID_26_19 GND sg13_lv_nmos W=0.3u L=0.13u
MMW_26_20 WBL[20] WWL[26] SN_26_20 GND sg13_hv_nmos W=0.15u L=0.45u
MMS_26_20 MID_26_20 SN_26_20 GND GND sg13_lv_nmos W=0.3u L=0.13u
MMR_26_20 RBL[20] RWL[26] MID_26_20 GND sg13_lv_nmos W=0.3u L=0.13u
MMW_26_21 WBL[21] WWL[26] SN_26_21 GND sg13_hv_nmos W=0.15u L=0.45u
MMS_26_21 MID_26_21 SN_26_21 GND GND sg13_lv_nmos W=0.3u L=0.13u
MMR_26_21 RBL[21] RWL[26] MID_26_21 GND sg13_lv_nmos W=0.3u L=0.13u
MMW_26_22 WBL[22] WWL[26] SN_26_22 GND sg13_hv_nmos W=0.15u L=0.45u
MMS_26_22 MID_26_22 SN_26_22 GND GND sg13_lv_nmos W=0.3u L=0.13u
MMR_26_22 RBL[22] RWL[26] MID_26_22 GND sg13_lv_nmos W=0.3u L=0.13u
MMW_26_23 WBL[23] WWL[26] SN_26_23 GND sg13_hv_nmos W=0.15u L=0.45u
MMS_26_23 MID_26_23 SN_26_23 GND GND sg13_lv_nmos W=0.3u L=0.13u
MMR_26_23 RBL[23] RWL[26] MID_26_23 GND sg13_lv_nmos W=0.3u L=0.13u
MMW_26_24 WBL[24] WWL[26] SN_26_24 GND sg13_hv_nmos W=0.15u L=0.45u
MMS_26_24 MID_26_24 SN_26_24 GND GND sg13_lv_nmos W=0.3u L=0.13u
MMR_26_24 RBL[24] RWL[26] MID_26_24 GND sg13_lv_nmos W=0.3u L=0.13u
MMW_26_25 WBL[25] WWL[26] SN_26_25 GND sg13_hv_nmos W=0.15u L=0.45u
MMS_26_25 MID_26_25 SN_26_25 GND GND sg13_lv_nmos W=0.3u L=0.13u
MMR_26_25 RBL[25] RWL[26] MID_26_25 GND sg13_lv_nmos W=0.3u L=0.13u
MMW_26_26 WBL[26] WWL[26] SN_26_26 GND sg13_hv_nmos W=0.15u L=0.45u
MMS_26_26 MID_26_26 SN_26_26 GND GND sg13_lv_nmos W=0.3u L=0.13u
MMR_26_26 RBL[26] RWL[26] MID_26_26 GND sg13_lv_nmos W=0.3u L=0.13u
MMW_26_27 WBL[27] WWL[26] SN_26_27 GND sg13_hv_nmos W=0.15u L=0.45u
MMS_26_27 MID_26_27 SN_26_27 GND GND sg13_lv_nmos W=0.3u L=0.13u
MMR_26_27 RBL[27] RWL[26] MID_26_27 GND sg13_lv_nmos W=0.3u L=0.13u
MMW_26_28 WBL[28] WWL[26] SN_26_28 GND sg13_hv_nmos W=0.15u L=0.45u
MMS_26_28 MID_26_28 SN_26_28 GND GND sg13_lv_nmos W=0.3u L=0.13u
MMR_26_28 RBL[28] RWL[26] MID_26_28 GND sg13_lv_nmos W=0.3u L=0.13u
MMW_26_29 WBL[29] WWL[26] SN_26_29 GND sg13_hv_nmos W=0.15u L=0.45u
MMS_26_29 MID_26_29 SN_26_29 GND GND sg13_lv_nmos W=0.3u L=0.13u
MMR_26_29 RBL[29] RWL[26] MID_26_29 GND sg13_lv_nmos W=0.3u L=0.13u
MMW_26_30 WBL[30] WWL[26] SN_26_30 GND sg13_hv_nmos W=0.15u L=0.45u
MMS_26_30 MID_26_30 SN_26_30 GND GND sg13_lv_nmos W=0.3u L=0.13u
MMR_26_30 RBL[30] RWL[26] MID_26_30 GND sg13_lv_nmos W=0.3u L=0.13u
MMW_26_31 WBL[31] WWL[26] SN_26_31 GND sg13_hv_nmos W=0.15u L=0.45u
MMS_26_31 MID_26_31 SN_26_31 GND GND sg13_lv_nmos W=0.3u L=0.13u
MMR_26_31 RBL[31] RWL[26] MID_26_31 GND sg13_lv_nmos W=0.3u L=0.13u
MMW_26_32 WBL[32] WWL[26] SN_26_32 GND sg13_hv_nmos W=0.15u L=0.45u
MMS_26_32 MID_26_32 SN_26_32 GND GND sg13_lv_nmos W=0.3u L=0.13u
MMR_26_32 RBL[32] RWL[26] MID_26_32 GND sg13_lv_nmos W=0.3u L=0.13u
MMW_26_33 WBL[33] WWL[26] SN_26_33 GND sg13_hv_nmos W=0.15u L=0.45u
MMS_26_33 MID_26_33 SN_26_33 GND GND sg13_lv_nmos W=0.3u L=0.13u
MMR_26_33 RBL[33] RWL[26] MID_26_33 GND sg13_lv_nmos W=0.3u L=0.13u
MMW_26_34 WBL[34] WWL[26] SN_26_34 GND sg13_hv_nmos W=0.15u L=0.45u
MMS_26_34 MID_26_34 SN_26_34 GND GND sg13_lv_nmos W=0.3u L=0.13u
MMR_26_34 RBL[34] RWL[26] MID_26_34 GND sg13_lv_nmos W=0.3u L=0.13u
MMW_26_35 WBL[35] WWL[26] SN_26_35 GND sg13_hv_nmos W=0.15u L=0.45u
MMS_26_35 MID_26_35 SN_26_35 GND GND sg13_lv_nmos W=0.3u L=0.13u
MMR_26_35 RBL[35] RWL[26] MID_26_35 GND sg13_lv_nmos W=0.3u L=0.13u
MMW_26_36 WBL[36] WWL[26] SN_26_36 GND sg13_hv_nmos W=0.15u L=0.45u
MMS_26_36 MID_26_36 SN_26_36 GND GND sg13_lv_nmos W=0.3u L=0.13u
MMR_26_36 RBL[36] RWL[26] MID_26_36 GND sg13_lv_nmos W=0.3u L=0.13u
MMW_26_37 WBL[37] WWL[26] SN_26_37 GND sg13_hv_nmos W=0.15u L=0.45u
MMS_26_37 MID_26_37 SN_26_37 GND GND sg13_lv_nmos W=0.3u L=0.13u
MMR_26_37 RBL[37] RWL[26] MID_26_37 GND sg13_lv_nmos W=0.3u L=0.13u
MMW_27_0 WBL[0] WWL[27] SN_27_0 GND sg13_hv_nmos W=0.15u L=0.45u
MMS_27_0 MID_27_0 SN_27_0 GND GND sg13_lv_nmos W=0.3u L=0.13u
MMR_27_0 RBL[0] RWL[27] MID_27_0 GND sg13_lv_nmos W=0.3u L=0.13u
MMW_27_1 WBL[1] WWL[27] SN_27_1 GND sg13_hv_nmos W=0.15u L=0.45u
MMS_27_1 MID_27_1 SN_27_1 GND GND sg13_lv_nmos W=0.3u L=0.13u
MMR_27_1 RBL[1] RWL[27] MID_27_1 GND sg13_lv_nmos W=0.3u L=0.13u
MMW_27_2 WBL[2] WWL[27] SN_27_2 GND sg13_hv_nmos W=0.15u L=0.45u
MMS_27_2 MID_27_2 SN_27_2 GND GND sg13_lv_nmos W=0.3u L=0.13u
MMR_27_2 RBL[2] RWL[27] MID_27_2 GND sg13_lv_nmos W=0.3u L=0.13u
MMW_27_3 WBL[3] WWL[27] SN_27_3 GND sg13_hv_nmos W=0.15u L=0.45u
MMS_27_3 MID_27_3 SN_27_3 GND GND sg13_lv_nmos W=0.3u L=0.13u
MMR_27_3 RBL[3] RWL[27] MID_27_3 GND sg13_lv_nmos W=0.3u L=0.13u
MMW_27_4 WBL[4] WWL[27] SN_27_4 GND sg13_hv_nmos W=0.15u L=0.45u
MMS_27_4 MID_27_4 SN_27_4 GND GND sg13_lv_nmos W=0.3u L=0.13u
MMR_27_4 RBL[4] RWL[27] MID_27_4 GND sg13_lv_nmos W=0.3u L=0.13u
MMW_27_5 WBL[5] WWL[27] SN_27_5 GND sg13_hv_nmos W=0.15u L=0.45u
MMS_27_5 MID_27_5 SN_27_5 GND GND sg13_lv_nmos W=0.3u L=0.13u
MMR_27_5 RBL[5] RWL[27] MID_27_5 GND sg13_lv_nmos W=0.3u L=0.13u
MMW_27_6 WBL[6] WWL[27] SN_27_6 GND sg13_hv_nmos W=0.15u L=0.45u
MMS_27_6 MID_27_6 SN_27_6 GND GND sg13_lv_nmos W=0.3u L=0.13u
MMR_27_6 RBL[6] RWL[27] MID_27_6 GND sg13_lv_nmos W=0.3u L=0.13u
MMW_27_7 WBL[7] WWL[27] SN_27_7 GND sg13_hv_nmos W=0.15u L=0.45u
MMS_27_7 MID_27_7 SN_27_7 GND GND sg13_lv_nmos W=0.3u L=0.13u
MMR_27_7 RBL[7] RWL[27] MID_27_7 GND sg13_lv_nmos W=0.3u L=0.13u
MMW_27_8 WBL[8] WWL[27] SN_27_8 GND sg13_hv_nmos W=0.15u L=0.45u
MMS_27_8 MID_27_8 SN_27_8 GND GND sg13_lv_nmos W=0.3u L=0.13u
MMR_27_8 RBL[8] RWL[27] MID_27_8 GND sg13_lv_nmos W=0.3u L=0.13u
MMW_27_9 WBL[9] WWL[27] SN_27_9 GND sg13_hv_nmos W=0.15u L=0.45u
MMS_27_9 MID_27_9 SN_27_9 GND GND sg13_lv_nmos W=0.3u L=0.13u
MMR_27_9 RBL[9] RWL[27] MID_27_9 GND sg13_lv_nmos W=0.3u L=0.13u
MMW_27_10 WBL[10] WWL[27] SN_27_10 GND sg13_hv_nmos W=0.15u L=0.45u
MMS_27_10 MID_27_10 SN_27_10 GND GND sg13_lv_nmos W=0.3u L=0.13u
MMR_27_10 RBL[10] RWL[27] MID_27_10 GND sg13_lv_nmos W=0.3u L=0.13u
MMW_27_11 WBL[11] WWL[27] SN_27_11 GND sg13_hv_nmos W=0.15u L=0.45u
MMS_27_11 MID_27_11 SN_27_11 GND GND sg13_lv_nmos W=0.3u L=0.13u
MMR_27_11 RBL[11] RWL[27] MID_27_11 GND sg13_lv_nmos W=0.3u L=0.13u
MMW_27_12 WBL[12] WWL[27] SN_27_12 GND sg13_hv_nmos W=0.15u L=0.45u
MMS_27_12 MID_27_12 SN_27_12 GND GND sg13_lv_nmos W=0.3u L=0.13u
MMR_27_12 RBL[12] RWL[27] MID_27_12 GND sg13_lv_nmos W=0.3u L=0.13u
MMW_27_13 WBL[13] WWL[27] SN_27_13 GND sg13_hv_nmos W=0.15u L=0.45u
MMS_27_13 MID_27_13 SN_27_13 GND GND sg13_lv_nmos W=0.3u L=0.13u
MMR_27_13 RBL[13] RWL[27] MID_27_13 GND sg13_lv_nmos W=0.3u L=0.13u
MMW_27_14 WBL[14] WWL[27] SN_27_14 GND sg13_hv_nmos W=0.15u L=0.45u
MMS_27_14 MID_27_14 SN_27_14 GND GND sg13_lv_nmos W=0.3u L=0.13u
MMR_27_14 RBL[14] RWL[27] MID_27_14 GND sg13_lv_nmos W=0.3u L=0.13u
MMW_27_15 WBL[15] WWL[27] SN_27_15 GND sg13_hv_nmos W=0.15u L=0.45u
MMS_27_15 MID_27_15 SN_27_15 GND GND sg13_lv_nmos W=0.3u L=0.13u
MMR_27_15 RBL[15] RWL[27] MID_27_15 GND sg13_lv_nmos W=0.3u L=0.13u
MMW_27_16 WBL[16] WWL[27] SN_27_16 GND sg13_hv_nmos W=0.15u L=0.45u
MMS_27_16 MID_27_16 SN_27_16 GND GND sg13_lv_nmos W=0.3u L=0.13u
MMR_27_16 RBL[16] RWL[27] MID_27_16 GND sg13_lv_nmos W=0.3u L=0.13u
MMW_27_17 WBL[17] WWL[27] SN_27_17 GND sg13_hv_nmos W=0.15u L=0.45u
MMS_27_17 MID_27_17 SN_27_17 GND GND sg13_lv_nmos W=0.3u L=0.13u
MMR_27_17 RBL[17] RWL[27] MID_27_17 GND sg13_lv_nmos W=0.3u L=0.13u
MMW_27_18 WBL[18] WWL[27] SN_27_18 GND sg13_hv_nmos W=0.15u L=0.45u
MMS_27_18 MID_27_18 SN_27_18 GND GND sg13_lv_nmos W=0.3u L=0.13u
MMR_27_18 RBL[18] RWL[27] MID_27_18 GND sg13_lv_nmos W=0.3u L=0.13u
MMW_27_19 WBL[19] WWL[27] SN_27_19 GND sg13_hv_nmos W=0.15u L=0.45u
MMS_27_19 MID_27_19 SN_27_19 GND GND sg13_lv_nmos W=0.3u L=0.13u
MMR_27_19 RBL[19] RWL[27] MID_27_19 GND sg13_lv_nmos W=0.3u L=0.13u
MMW_27_20 WBL[20] WWL[27] SN_27_20 GND sg13_hv_nmos W=0.15u L=0.45u
MMS_27_20 MID_27_20 SN_27_20 GND GND sg13_lv_nmos W=0.3u L=0.13u
MMR_27_20 RBL[20] RWL[27] MID_27_20 GND sg13_lv_nmos W=0.3u L=0.13u
MMW_27_21 WBL[21] WWL[27] SN_27_21 GND sg13_hv_nmos W=0.15u L=0.45u
MMS_27_21 MID_27_21 SN_27_21 GND GND sg13_lv_nmos W=0.3u L=0.13u
MMR_27_21 RBL[21] RWL[27] MID_27_21 GND sg13_lv_nmos W=0.3u L=0.13u
MMW_27_22 WBL[22] WWL[27] SN_27_22 GND sg13_hv_nmos W=0.15u L=0.45u
MMS_27_22 MID_27_22 SN_27_22 GND GND sg13_lv_nmos W=0.3u L=0.13u
MMR_27_22 RBL[22] RWL[27] MID_27_22 GND sg13_lv_nmos W=0.3u L=0.13u
MMW_27_23 WBL[23] WWL[27] SN_27_23 GND sg13_hv_nmos W=0.15u L=0.45u
MMS_27_23 MID_27_23 SN_27_23 GND GND sg13_lv_nmos W=0.3u L=0.13u
MMR_27_23 RBL[23] RWL[27] MID_27_23 GND sg13_lv_nmos W=0.3u L=0.13u
MMW_27_24 WBL[24] WWL[27] SN_27_24 GND sg13_hv_nmos W=0.15u L=0.45u
MMS_27_24 MID_27_24 SN_27_24 GND GND sg13_lv_nmos W=0.3u L=0.13u
MMR_27_24 RBL[24] RWL[27] MID_27_24 GND sg13_lv_nmos W=0.3u L=0.13u
MMW_27_25 WBL[25] WWL[27] SN_27_25 GND sg13_hv_nmos W=0.15u L=0.45u
MMS_27_25 MID_27_25 SN_27_25 GND GND sg13_lv_nmos W=0.3u L=0.13u
MMR_27_25 RBL[25] RWL[27] MID_27_25 GND sg13_lv_nmos W=0.3u L=0.13u
MMW_27_26 WBL[26] WWL[27] SN_27_26 GND sg13_hv_nmos W=0.15u L=0.45u
MMS_27_26 MID_27_26 SN_27_26 GND GND sg13_lv_nmos W=0.3u L=0.13u
MMR_27_26 RBL[26] RWL[27] MID_27_26 GND sg13_lv_nmos W=0.3u L=0.13u
MMW_27_27 WBL[27] WWL[27] SN_27_27 GND sg13_hv_nmos W=0.15u L=0.45u
MMS_27_27 MID_27_27 SN_27_27 GND GND sg13_lv_nmos W=0.3u L=0.13u
MMR_27_27 RBL[27] RWL[27] MID_27_27 GND sg13_lv_nmos W=0.3u L=0.13u
MMW_27_28 WBL[28] WWL[27] SN_27_28 GND sg13_hv_nmos W=0.15u L=0.45u
MMS_27_28 MID_27_28 SN_27_28 GND GND sg13_lv_nmos W=0.3u L=0.13u
MMR_27_28 RBL[28] RWL[27] MID_27_28 GND sg13_lv_nmos W=0.3u L=0.13u
MMW_27_29 WBL[29] WWL[27] SN_27_29 GND sg13_hv_nmos W=0.15u L=0.45u
MMS_27_29 MID_27_29 SN_27_29 GND GND sg13_lv_nmos W=0.3u L=0.13u
MMR_27_29 RBL[29] RWL[27] MID_27_29 GND sg13_lv_nmos W=0.3u L=0.13u
MMW_27_30 WBL[30] WWL[27] SN_27_30 GND sg13_hv_nmos W=0.15u L=0.45u
MMS_27_30 MID_27_30 SN_27_30 GND GND sg13_lv_nmos W=0.3u L=0.13u
MMR_27_30 RBL[30] RWL[27] MID_27_30 GND sg13_lv_nmos W=0.3u L=0.13u
MMW_27_31 WBL[31] WWL[27] SN_27_31 GND sg13_hv_nmos W=0.15u L=0.45u
MMS_27_31 MID_27_31 SN_27_31 GND GND sg13_lv_nmos W=0.3u L=0.13u
MMR_27_31 RBL[31] RWL[27] MID_27_31 GND sg13_lv_nmos W=0.3u L=0.13u
MMW_27_32 WBL[32] WWL[27] SN_27_32 GND sg13_hv_nmos W=0.15u L=0.45u
MMS_27_32 MID_27_32 SN_27_32 GND GND sg13_lv_nmos W=0.3u L=0.13u
MMR_27_32 RBL[32] RWL[27] MID_27_32 GND sg13_lv_nmos W=0.3u L=0.13u
MMW_27_33 WBL[33] WWL[27] SN_27_33 GND sg13_hv_nmos W=0.15u L=0.45u
MMS_27_33 MID_27_33 SN_27_33 GND GND sg13_lv_nmos W=0.3u L=0.13u
MMR_27_33 RBL[33] RWL[27] MID_27_33 GND sg13_lv_nmos W=0.3u L=0.13u
MMW_27_34 WBL[34] WWL[27] SN_27_34 GND sg13_hv_nmos W=0.15u L=0.45u
MMS_27_34 MID_27_34 SN_27_34 GND GND sg13_lv_nmos W=0.3u L=0.13u
MMR_27_34 RBL[34] RWL[27] MID_27_34 GND sg13_lv_nmos W=0.3u L=0.13u
MMW_27_35 WBL[35] WWL[27] SN_27_35 GND sg13_hv_nmos W=0.15u L=0.45u
MMS_27_35 MID_27_35 SN_27_35 GND GND sg13_lv_nmos W=0.3u L=0.13u
MMR_27_35 RBL[35] RWL[27] MID_27_35 GND sg13_lv_nmos W=0.3u L=0.13u
MMW_27_36 WBL[36] WWL[27] SN_27_36 GND sg13_hv_nmos W=0.15u L=0.45u
MMS_27_36 MID_27_36 SN_27_36 GND GND sg13_lv_nmos W=0.3u L=0.13u
MMR_27_36 RBL[36] RWL[27] MID_27_36 GND sg13_lv_nmos W=0.3u L=0.13u
MMW_27_37 WBL[37] WWL[27] SN_27_37 GND sg13_hv_nmos W=0.15u L=0.45u
MMS_27_37 MID_27_37 SN_27_37 GND GND sg13_lv_nmos W=0.3u L=0.13u
MMR_27_37 RBL[37] RWL[27] MID_27_37 GND sg13_lv_nmos W=0.3u L=0.13u
MMW_28_0 WBL[0] WWL[28] SN_28_0 GND sg13_hv_nmos W=0.15u L=0.45u
MMS_28_0 MID_28_0 SN_28_0 GND GND sg13_lv_nmos W=0.3u L=0.13u
MMR_28_0 RBL[0] RWL[28] MID_28_0 GND sg13_lv_nmos W=0.3u L=0.13u
MMW_28_1 WBL[1] WWL[28] SN_28_1 GND sg13_hv_nmos W=0.15u L=0.45u
MMS_28_1 MID_28_1 SN_28_1 GND GND sg13_lv_nmos W=0.3u L=0.13u
MMR_28_1 RBL[1] RWL[28] MID_28_1 GND sg13_lv_nmos W=0.3u L=0.13u
MMW_28_2 WBL[2] WWL[28] SN_28_2 GND sg13_hv_nmos W=0.15u L=0.45u
MMS_28_2 MID_28_2 SN_28_2 GND GND sg13_lv_nmos W=0.3u L=0.13u
MMR_28_2 RBL[2] RWL[28] MID_28_2 GND sg13_lv_nmos W=0.3u L=0.13u
MMW_28_3 WBL[3] WWL[28] SN_28_3 GND sg13_hv_nmos W=0.15u L=0.45u
MMS_28_3 MID_28_3 SN_28_3 GND GND sg13_lv_nmos W=0.3u L=0.13u
MMR_28_3 RBL[3] RWL[28] MID_28_3 GND sg13_lv_nmos W=0.3u L=0.13u
MMW_28_4 WBL[4] WWL[28] SN_28_4 GND sg13_hv_nmos W=0.15u L=0.45u
MMS_28_4 MID_28_4 SN_28_4 GND GND sg13_lv_nmos W=0.3u L=0.13u
MMR_28_4 RBL[4] RWL[28] MID_28_4 GND sg13_lv_nmos W=0.3u L=0.13u
MMW_28_5 WBL[5] WWL[28] SN_28_5 GND sg13_hv_nmos W=0.15u L=0.45u
MMS_28_5 MID_28_5 SN_28_5 GND GND sg13_lv_nmos W=0.3u L=0.13u
MMR_28_5 RBL[5] RWL[28] MID_28_5 GND sg13_lv_nmos W=0.3u L=0.13u
MMW_28_6 WBL[6] WWL[28] SN_28_6 GND sg13_hv_nmos W=0.15u L=0.45u
MMS_28_6 MID_28_6 SN_28_6 GND GND sg13_lv_nmos W=0.3u L=0.13u
MMR_28_6 RBL[6] RWL[28] MID_28_6 GND sg13_lv_nmos W=0.3u L=0.13u
MMW_28_7 WBL[7] WWL[28] SN_28_7 GND sg13_hv_nmos W=0.15u L=0.45u
MMS_28_7 MID_28_7 SN_28_7 GND GND sg13_lv_nmos W=0.3u L=0.13u
MMR_28_7 RBL[7] RWL[28] MID_28_7 GND sg13_lv_nmos W=0.3u L=0.13u
MMW_28_8 WBL[8] WWL[28] SN_28_8 GND sg13_hv_nmos W=0.15u L=0.45u
MMS_28_8 MID_28_8 SN_28_8 GND GND sg13_lv_nmos W=0.3u L=0.13u
MMR_28_8 RBL[8] RWL[28] MID_28_8 GND sg13_lv_nmos W=0.3u L=0.13u
MMW_28_9 WBL[9] WWL[28] SN_28_9 GND sg13_hv_nmos W=0.15u L=0.45u
MMS_28_9 MID_28_9 SN_28_9 GND GND sg13_lv_nmos W=0.3u L=0.13u
MMR_28_9 RBL[9] RWL[28] MID_28_9 GND sg13_lv_nmos W=0.3u L=0.13u
MMW_28_10 WBL[10] WWL[28] SN_28_10 GND sg13_hv_nmos W=0.15u L=0.45u
MMS_28_10 MID_28_10 SN_28_10 GND GND sg13_lv_nmos W=0.3u L=0.13u
MMR_28_10 RBL[10] RWL[28] MID_28_10 GND sg13_lv_nmos W=0.3u L=0.13u
MMW_28_11 WBL[11] WWL[28] SN_28_11 GND sg13_hv_nmos W=0.15u L=0.45u
MMS_28_11 MID_28_11 SN_28_11 GND GND sg13_lv_nmos W=0.3u L=0.13u
MMR_28_11 RBL[11] RWL[28] MID_28_11 GND sg13_lv_nmos W=0.3u L=0.13u
MMW_28_12 WBL[12] WWL[28] SN_28_12 GND sg13_hv_nmos W=0.15u L=0.45u
MMS_28_12 MID_28_12 SN_28_12 GND GND sg13_lv_nmos W=0.3u L=0.13u
MMR_28_12 RBL[12] RWL[28] MID_28_12 GND sg13_lv_nmos W=0.3u L=0.13u
MMW_28_13 WBL[13] WWL[28] SN_28_13 GND sg13_hv_nmos W=0.15u L=0.45u
MMS_28_13 MID_28_13 SN_28_13 GND GND sg13_lv_nmos W=0.3u L=0.13u
MMR_28_13 RBL[13] RWL[28] MID_28_13 GND sg13_lv_nmos W=0.3u L=0.13u
MMW_28_14 WBL[14] WWL[28] SN_28_14 GND sg13_hv_nmos W=0.15u L=0.45u
MMS_28_14 MID_28_14 SN_28_14 GND GND sg13_lv_nmos W=0.3u L=0.13u
MMR_28_14 RBL[14] RWL[28] MID_28_14 GND sg13_lv_nmos W=0.3u L=0.13u
MMW_28_15 WBL[15] WWL[28] SN_28_15 GND sg13_hv_nmos W=0.15u L=0.45u
MMS_28_15 MID_28_15 SN_28_15 GND GND sg13_lv_nmos W=0.3u L=0.13u
MMR_28_15 RBL[15] RWL[28] MID_28_15 GND sg13_lv_nmos W=0.3u L=0.13u
MMW_28_16 WBL[16] WWL[28] SN_28_16 GND sg13_hv_nmos W=0.15u L=0.45u
MMS_28_16 MID_28_16 SN_28_16 GND GND sg13_lv_nmos W=0.3u L=0.13u
MMR_28_16 RBL[16] RWL[28] MID_28_16 GND sg13_lv_nmos W=0.3u L=0.13u
MMW_28_17 WBL[17] WWL[28] SN_28_17 GND sg13_hv_nmos W=0.15u L=0.45u
MMS_28_17 MID_28_17 SN_28_17 GND GND sg13_lv_nmos W=0.3u L=0.13u
MMR_28_17 RBL[17] RWL[28] MID_28_17 GND sg13_lv_nmos W=0.3u L=0.13u
MMW_28_18 WBL[18] WWL[28] SN_28_18 GND sg13_hv_nmos W=0.15u L=0.45u
MMS_28_18 MID_28_18 SN_28_18 GND GND sg13_lv_nmos W=0.3u L=0.13u
MMR_28_18 RBL[18] RWL[28] MID_28_18 GND sg13_lv_nmos W=0.3u L=0.13u
MMW_28_19 WBL[19] WWL[28] SN_28_19 GND sg13_hv_nmos W=0.15u L=0.45u
MMS_28_19 MID_28_19 SN_28_19 GND GND sg13_lv_nmos W=0.3u L=0.13u
MMR_28_19 RBL[19] RWL[28] MID_28_19 GND sg13_lv_nmos W=0.3u L=0.13u
MMW_28_20 WBL[20] WWL[28] SN_28_20 GND sg13_hv_nmos W=0.15u L=0.45u
MMS_28_20 MID_28_20 SN_28_20 GND GND sg13_lv_nmos W=0.3u L=0.13u
MMR_28_20 RBL[20] RWL[28] MID_28_20 GND sg13_lv_nmos W=0.3u L=0.13u
MMW_28_21 WBL[21] WWL[28] SN_28_21 GND sg13_hv_nmos W=0.15u L=0.45u
MMS_28_21 MID_28_21 SN_28_21 GND GND sg13_lv_nmos W=0.3u L=0.13u
MMR_28_21 RBL[21] RWL[28] MID_28_21 GND sg13_lv_nmos W=0.3u L=0.13u
MMW_28_22 WBL[22] WWL[28] SN_28_22 GND sg13_hv_nmos W=0.15u L=0.45u
MMS_28_22 MID_28_22 SN_28_22 GND GND sg13_lv_nmos W=0.3u L=0.13u
MMR_28_22 RBL[22] RWL[28] MID_28_22 GND sg13_lv_nmos W=0.3u L=0.13u
MMW_28_23 WBL[23] WWL[28] SN_28_23 GND sg13_hv_nmos W=0.15u L=0.45u
MMS_28_23 MID_28_23 SN_28_23 GND GND sg13_lv_nmos W=0.3u L=0.13u
MMR_28_23 RBL[23] RWL[28] MID_28_23 GND sg13_lv_nmos W=0.3u L=0.13u
MMW_28_24 WBL[24] WWL[28] SN_28_24 GND sg13_hv_nmos W=0.15u L=0.45u
MMS_28_24 MID_28_24 SN_28_24 GND GND sg13_lv_nmos W=0.3u L=0.13u
MMR_28_24 RBL[24] RWL[28] MID_28_24 GND sg13_lv_nmos W=0.3u L=0.13u
MMW_28_25 WBL[25] WWL[28] SN_28_25 GND sg13_hv_nmos W=0.15u L=0.45u
MMS_28_25 MID_28_25 SN_28_25 GND GND sg13_lv_nmos W=0.3u L=0.13u
MMR_28_25 RBL[25] RWL[28] MID_28_25 GND sg13_lv_nmos W=0.3u L=0.13u
MMW_28_26 WBL[26] WWL[28] SN_28_26 GND sg13_hv_nmos W=0.15u L=0.45u
MMS_28_26 MID_28_26 SN_28_26 GND GND sg13_lv_nmos W=0.3u L=0.13u
MMR_28_26 RBL[26] RWL[28] MID_28_26 GND sg13_lv_nmos W=0.3u L=0.13u
MMW_28_27 WBL[27] WWL[28] SN_28_27 GND sg13_hv_nmos W=0.15u L=0.45u
MMS_28_27 MID_28_27 SN_28_27 GND GND sg13_lv_nmos W=0.3u L=0.13u
MMR_28_27 RBL[27] RWL[28] MID_28_27 GND sg13_lv_nmos W=0.3u L=0.13u
MMW_28_28 WBL[28] WWL[28] SN_28_28 GND sg13_hv_nmos W=0.15u L=0.45u
MMS_28_28 MID_28_28 SN_28_28 GND GND sg13_lv_nmos W=0.3u L=0.13u
MMR_28_28 RBL[28] RWL[28] MID_28_28 GND sg13_lv_nmos W=0.3u L=0.13u
MMW_28_29 WBL[29] WWL[28] SN_28_29 GND sg13_hv_nmos W=0.15u L=0.45u
MMS_28_29 MID_28_29 SN_28_29 GND GND sg13_lv_nmos W=0.3u L=0.13u
MMR_28_29 RBL[29] RWL[28] MID_28_29 GND sg13_lv_nmos W=0.3u L=0.13u
MMW_28_30 WBL[30] WWL[28] SN_28_30 GND sg13_hv_nmos W=0.15u L=0.45u
MMS_28_30 MID_28_30 SN_28_30 GND GND sg13_lv_nmos W=0.3u L=0.13u
MMR_28_30 RBL[30] RWL[28] MID_28_30 GND sg13_lv_nmos W=0.3u L=0.13u
MMW_28_31 WBL[31] WWL[28] SN_28_31 GND sg13_hv_nmos W=0.15u L=0.45u
MMS_28_31 MID_28_31 SN_28_31 GND GND sg13_lv_nmos W=0.3u L=0.13u
MMR_28_31 RBL[31] RWL[28] MID_28_31 GND sg13_lv_nmos W=0.3u L=0.13u
MMW_28_32 WBL[32] WWL[28] SN_28_32 GND sg13_hv_nmos W=0.15u L=0.45u
MMS_28_32 MID_28_32 SN_28_32 GND GND sg13_lv_nmos W=0.3u L=0.13u
MMR_28_32 RBL[32] RWL[28] MID_28_32 GND sg13_lv_nmos W=0.3u L=0.13u
MMW_28_33 WBL[33] WWL[28] SN_28_33 GND sg13_hv_nmos W=0.15u L=0.45u
MMS_28_33 MID_28_33 SN_28_33 GND GND sg13_lv_nmos W=0.3u L=0.13u
MMR_28_33 RBL[33] RWL[28] MID_28_33 GND sg13_lv_nmos W=0.3u L=0.13u
MMW_28_34 WBL[34] WWL[28] SN_28_34 GND sg13_hv_nmos W=0.15u L=0.45u
MMS_28_34 MID_28_34 SN_28_34 GND GND sg13_lv_nmos W=0.3u L=0.13u
MMR_28_34 RBL[34] RWL[28] MID_28_34 GND sg13_lv_nmos W=0.3u L=0.13u
MMW_28_35 WBL[35] WWL[28] SN_28_35 GND sg13_hv_nmos W=0.15u L=0.45u
MMS_28_35 MID_28_35 SN_28_35 GND GND sg13_lv_nmos W=0.3u L=0.13u
MMR_28_35 RBL[35] RWL[28] MID_28_35 GND sg13_lv_nmos W=0.3u L=0.13u
MMW_28_36 WBL[36] WWL[28] SN_28_36 GND sg13_hv_nmos W=0.15u L=0.45u
MMS_28_36 MID_28_36 SN_28_36 GND GND sg13_lv_nmos W=0.3u L=0.13u
MMR_28_36 RBL[36] RWL[28] MID_28_36 GND sg13_lv_nmos W=0.3u L=0.13u
MMW_28_37 WBL[37] WWL[28] SN_28_37 GND sg13_hv_nmos W=0.15u L=0.45u
MMS_28_37 MID_28_37 SN_28_37 GND GND sg13_lv_nmos W=0.3u L=0.13u
MMR_28_37 RBL[37] RWL[28] MID_28_37 GND sg13_lv_nmos W=0.3u L=0.13u
MMW_29_0 WBL[0] WWL[29] SN_29_0 GND sg13_hv_nmos W=0.15u L=0.45u
MMS_29_0 MID_29_0 SN_29_0 GND GND sg13_lv_nmos W=0.3u L=0.13u
MMR_29_0 RBL[0] RWL[29] MID_29_0 GND sg13_lv_nmos W=0.3u L=0.13u
MMW_29_1 WBL[1] WWL[29] SN_29_1 GND sg13_hv_nmos W=0.15u L=0.45u
MMS_29_1 MID_29_1 SN_29_1 GND GND sg13_lv_nmos W=0.3u L=0.13u
MMR_29_1 RBL[1] RWL[29] MID_29_1 GND sg13_lv_nmos W=0.3u L=0.13u
MMW_29_2 WBL[2] WWL[29] SN_29_2 GND sg13_hv_nmos W=0.15u L=0.45u
MMS_29_2 MID_29_2 SN_29_2 GND GND sg13_lv_nmos W=0.3u L=0.13u
MMR_29_2 RBL[2] RWL[29] MID_29_2 GND sg13_lv_nmos W=0.3u L=0.13u
MMW_29_3 WBL[3] WWL[29] SN_29_3 GND sg13_hv_nmos W=0.15u L=0.45u
MMS_29_3 MID_29_3 SN_29_3 GND GND sg13_lv_nmos W=0.3u L=0.13u
MMR_29_3 RBL[3] RWL[29] MID_29_3 GND sg13_lv_nmos W=0.3u L=0.13u
MMW_29_4 WBL[4] WWL[29] SN_29_4 GND sg13_hv_nmos W=0.15u L=0.45u
MMS_29_4 MID_29_4 SN_29_4 GND GND sg13_lv_nmos W=0.3u L=0.13u
MMR_29_4 RBL[4] RWL[29] MID_29_4 GND sg13_lv_nmos W=0.3u L=0.13u
MMW_29_5 WBL[5] WWL[29] SN_29_5 GND sg13_hv_nmos W=0.15u L=0.45u
MMS_29_5 MID_29_5 SN_29_5 GND GND sg13_lv_nmos W=0.3u L=0.13u
MMR_29_5 RBL[5] RWL[29] MID_29_5 GND sg13_lv_nmos W=0.3u L=0.13u
MMW_29_6 WBL[6] WWL[29] SN_29_6 GND sg13_hv_nmos W=0.15u L=0.45u
MMS_29_6 MID_29_6 SN_29_6 GND GND sg13_lv_nmos W=0.3u L=0.13u
MMR_29_6 RBL[6] RWL[29] MID_29_6 GND sg13_lv_nmos W=0.3u L=0.13u
MMW_29_7 WBL[7] WWL[29] SN_29_7 GND sg13_hv_nmos W=0.15u L=0.45u
MMS_29_7 MID_29_7 SN_29_7 GND GND sg13_lv_nmos W=0.3u L=0.13u
MMR_29_7 RBL[7] RWL[29] MID_29_7 GND sg13_lv_nmos W=0.3u L=0.13u
MMW_29_8 WBL[8] WWL[29] SN_29_8 GND sg13_hv_nmos W=0.15u L=0.45u
MMS_29_8 MID_29_8 SN_29_8 GND GND sg13_lv_nmos W=0.3u L=0.13u
MMR_29_8 RBL[8] RWL[29] MID_29_8 GND sg13_lv_nmos W=0.3u L=0.13u
MMW_29_9 WBL[9] WWL[29] SN_29_9 GND sg13_hv_nmos W=0.15u L=0.45u
MMS_29_9 MID_29_9 SN_29_9 GND GND sg13_lv_nmos W=0.3u L=0.13u
MMR_29_9 RBL[9] RWL[29] MID_29_9 GND sg13_lv_nmos W=0.3u L=0.13u
MMW_29_10 WBL[10] WWL[29] SN_29_10 GND sg13_hv_nmos W=0.15u L=0.45u
MMS_29_10 MID_29_10 SN_29_10 GND GND sg13_lv_nmos W=0.3u L=0.13u
MMR_29_10 RBL[10] RWL[29] MID_29_10 GND sg13_lv_nmos W=0.3u L=0.13u
MMW_29_11 WBL[11] WWL[29] SN_29_11 GND sg13_hv_nmos W=0.15u L=0.45u
MMS_29_11 MID_29_11 SN_29_11 GND GND sg13_lv_nmos W=0.3u L=0.13u
MMR_29_11 RBL[11] RWL[29] MID_29_11 GND sg13_lv_nmos W=0.3u L=0.13u
MMW_29_12 WBL[12] WWL[29] SN_29_12 GND sg13_hv_nmos W=0.15u L=0.45u
MMS_29_12 MID_29_12 SN_29_12 GND GND sg13_lv_nmos W=0.3u L=0.13u
MMR_29_12 RBL[12] RWL[29] MID_29_12 GND sg13_lv_nmos W=0.3u L=0.13u
MMW_29_13 WBL[13] WWL[29] SN_29_13 GND sg13_hv_nmos W=0.15u L=0.45u
MMS_29_13 MID_29_13 SN_29_13 GND GND sg13_lv_nmos W=0.3u L=0.13u
MMR_29_13 RBL[13] RWL[29] MID_29_13 GND sg13_lv_nmos W=0.3u L=0.13u
MMW_29_14 WBL[14] WWL[29] SN_29_14 GND sg13_hv_nmos W=0.15u L=0.45u
MMS_29_14 MID_29_14 SN_29_14 GND GND sg13_lv_nmos W=0.3u L=0.13u
MMR_29_14 RBL[14] RWL[29] MID_29_14 GND sg13_lv_nmos W=0.3u L=0.13u
MMW_29_15 WBL[15] WWL[29] SN_29_15 GND sg13_hv_nmos W=0.15u L=0.45u
MMS_29_15 MID_29_15 SN_29_15 GND GND sg13_lv_nmos W=0.3u L=0.13u
MMR_29_15 RBL[15] RWL[29] MID_29_15 GND sg13_lv_nmos W=0.3u L=0.13u
MMW_29_16 WBL[16] WWL[29] SN_29_16 GND sg13_hv_nmos W=0.15u L=0.45u
MMS_29_16 MID_29_16 SN_29_16 GND GND sg13_lv_nmos W=0.3u L=0.13u
MMR_29_16 RBL[16] RWL[29] MID_29_16 GND sg13_lv_nmos W=0.3u L=0.13u
MMW_29_17 WBL[17] WWL[29] SN_29_17 GND sg13_hv_nmos W=0.15u L=0.45u
MMS_29_17 MID_29_17 SN_29_17 GND GND sg13_lv_nmos W=0.3u L=0.13u
MMR_29_17 RBL[17] RWL[29] MID_29_17 GND sg13_lv_nmos W=0.3u L=0.13u
MMW_29_18 WBL[18] WWL[29] SN_29_18 GND sg13_hv_nmos W=0.15u L=0.45u
MMS_29_18 MID_29_18 SN_29_18 GND GND sg13_lv_nmos W=0.3u L=0.13u
MMR_29_18 RBL[18] RWL[29] MID_29_18 GND sg13_lv_nmos W=0.3u L=0.13u
MMW_29_19 WBL[19] WWL[29] SN_29_19 GND sg13_hv_nmos W=0.15u L=0.45u
MMS_29_19 MID_29_19 SN_29_19 GND GND sg13_lv_nmos W=0.3u L=0.13u
MMR_29_19 RBL[19] RWL[29] MID_29_19 GND sg13_lv_nmos W=0.3u L=0.13u
MMW_29_20 WBL[20] WWL[29] SN_29_20 GND sg13_hv_nmos W=0.15u L=0.45u
MMS_29_20 MID_29_20 SN_29_20 GND GND sg13_lv_nmos W=0.3u L=0.13u
MMR_29_20 RBL[20] RWL[29] MID_29_20 GND sg13_lv_nmos W=0.3u L=0.13u
MMW_29_21 WBL[21] WWL[29] SN_29_21 GND sg13_hv_nmos W=0.15u L=0.45u
MMS_29_21 MID_29_21 SN_29_21 GND GND sg13_lv_nmos W=0.3u L=0.13u
MMR_29_21 RBL[21] RWL[29] MID_29_21 GND sg13_lv_nmos W=0.3u L=0.13u
MMW_29_22 WBL[22] WWL[29] SN_29_22 GND sg13_hv_nmos W=0.15u L=0.45u
MMS_29_22 MID_29_22 SN_29_22 GND GND sg13_lv_nmos W=0.3u L=0.13u
MMR_29_22 RBL[22] RWL[29] MID_29_22 GND sg13_lv_nmos W=0.3u L=0.13u
MMW_29_23 WBL[23] WWL[29] SN_29_23 GND sg13_hv_nmos W=0.15u L=0.45u
MMS_29_23 MID_29_23 SN_29_23 GND GND sg13_lv_nmos W=0.3u L=0.13u
MMR_29_23 RBL[23] RWL[29] MID_29_23 GND sg13_lv_nmos W=0.3u L=0.13u
MMW_29_24 WBL[24] WWL[29] SN_29_24 GND sg13_hv_nmos W=0.15u L=0.45u
MMS_29_24 MID_29_24 SN_29_24 GND GND sg13_lv_nmos W=0.3u L=0.13u
MMR_29_24 RBL[24] RWL[29] MID_29_24 GND sg13_lv_nmos W=0.3u L=0.13u
MMW_29_25 WBL[25] WWL[29] SN_29_25 GND sg13_hv_nmos W=0.15u L=0.45u
MMS_29_25 MID_29_25 SN_29_25 GND GND sg13_lv_nmos W=0.3u L=0.13u
MMR_29_25 RBL[25] RWL[29] MID_29_25 GND sg13_lv_nmos W=0.3u L=0.13u
MMW_29_26 WBL[26] WWL[29] SN_29_26 GND sg13_hv_nmos W=0.15u L=0.45u
MMS_29_26 MID_29_26 SN_29_26 GND GND sg13_lv_nmos W=0.3u L=0.13u
MMR_29_26 RBL[26] RWL[29] MID_29_26 GND sg13_lv_nmos W=0.3u L=0.13u
MMW_29_27 WBL[27] WWL[29] SN_29_27 GND sg13_hv_nmos W=0.15u L=0.45u
MMS_29_27 MID_29_27 SN_29_27 GND GND sg13_lv_nmos W=0.3u L=0.13u
MMR_29_27 RBL[27] RWL[29] MID_29_27 GND sg13_lv_nmos W=0.3u L=0.13u
MMW_29_28 WBL[28] WWL[29] SN_29_28 GND sg13_hv_nmos W=0.15u L=0.45u
MMS_29_28 MID_29_28 SN_29_28 GND GND sg13_lv_nmos W=0.3u L=0.13u
MMR_29_28 RBL[28] RWL[29] MID_29_28 GND sg13_lv_nmos W=0.3u L=0.13u
MMW_29_29 WBL[29] WWL[29] SN_29_29 GND sg13_hv_nmos W=0.15u L=0.45u
MMS_29_29 MID_29_29 SN_29_29 GND GND sg13_lv_nmos W=0.3u L=0.13u
MMR_29_29 RBL[29] RWL[29] MID_29_29 GND sg13_lv_nmos W=0.3u L=0.13u
MMW_29_30 WBL[30] WWL[29] SN_29_30 GND sg13_hv_nmos W=0.15u L=0.45u
MMS_29_30 MID_29_30 SN_29_30 GND GND sg13_lv_nmos W=0.3u L=0.13u
MMR_29_30 RBL[30] RWL[29] MID_29_30 GND sg13_lv_nmos W=0.3u L=0.13u
MMW_29_31 WBL[31] WWL[29] SN_29_31 GND sg13_hv_nmos W=0.15u L=0.45u
MMS_29_31 MID_29_31 SN_29_31 GND GND sg13_lv_nmos W=0.3u L=0.13u
MMR_29_31 RBL[31] RWL[29] MID_29_31 GND sg13_lv_nmos W=0.3u L=0.13u
MMW_29_32 WBL[32] WWL[29] SN_29_32 GND sg13_hv_nmos W=0.15u L=0.45u
MMS_29_32 MID_29_32 SN_29_32 GND GND sg13_lv_nmos W=0.3u L=0.13u
MMR_29_32 RBL[32] RWL[29] MID_29_32 GND sg13_lv_nmos W=0.3u L=0.13u
MMW_29_33 WBL[33] WWL[29] SN_29_33 GND sg13_hv_nmos W=0.15u L=0.45u
MMS_29_33 MID_29_33 SN_29_33 GND GND sg13_lv_nmos W=0.3u L=0.13u
MMR_29_33 RBL[33] RWL[29] MID_29_33 GND sg13_lv_nmos W=0.3u L=0.13u
MMW_29_34 WBL[34] WWL[29] SN_29_34 GND sg13_hv_nmos W=0.15u L=0.45u
MMS_29_34 MID_29_34 SN_29_34 GND GND sg13_lv_nmos W=0.3u L=0.13u
MMR_29_34 RBL[34] RWL[29] MID_29_34 GND sg13_lv_nmos W=0.3u L=0.13u
MMW_29_35 WBL[35] WWL[29] SN_29_35 GND sg13_hv_nmos W=0.15u L=0.45u
MMS_29_35 MID_29_35 SN_29_35 GND GND sg13_lv_nmos W=0.3u L=0.13u
MMR_29_35 RBL[35] RWL[29] MID_29_35 GND sg13_lv_nmos W=0.3u L=0.13u
MMW_29_36 WBL[36] WWL[29] SN_29_36 GND sg13_hv_nmos W=0.15u L=0.45u
MMS_29_36 MID_29_36 SN_29_36 GND GND sg13_lv_nmos W=0.3u L=0.13u
MMR_29_36 RBL[36] RWL[29] MID_29_36 GND sg13_lv_nmos W=0.3u L=0.13u
MMW_29_37 WBL[37] WWL[29] SN_29_37 GND sg13_hv_nmos W=0.15u L=0.45u
MMS_29_37 MID_29_37 SN_29_37 GND GND sg13_lv_nmos W=0.3u L=0.13u
MMR_29_37 RBL[37] RWL[29] MID_29_37 GND sg13_lv_nmos W=0.3u L=0.13u
MMW_30_0 WBL[0] WWL[30] SN_30_0 GND sg13_hv_nmos W=0.15u L=0.45u
MMS_30_0 MID_30_0 SN_30_0 GND GND sg13_lv_nmos W=0.3u L=0.13u
MMR_30_0 RBL[0] RWL[30] MID_30_0 GND sg13_lv_nmos W=0.3u L=0.13u
MMW_30_1 WBL[1] WWL[30] SN_30_1 GND sg13_hv_nmos W=0.15u L=0.45u
MMS_30_1 MID_30_1 SN_30_1 GND GND sg13_lv_nmos W=0.3u L=0.13u
MMR_30_1 RBL[1] RWL[30] MID_30_1 GND sg13_lv_nmos W=0.3u L=0.13u
MMW_30_2 WBL[2] WWL[30] SN_30_2 GND sg13_hv_nmos W=0.15u L=0.45u
MMS_30_2 MID_30_2 SN_30_2 GND GND sg13_lv_nmos W=0.3u L=0.13u
MMR_30_2 RBL[2] RWL[30] MID_30_2 GND sg13_lv_nmos W=0.3u L=0.13u
MMW_30_3 WBL[3] WWL[30] SN_30_3 GND sg13_hv_nmos W=0.15u L=0.45u
MMS_30_3 MID_30_3 SN_30_3 GND GND sg13_lv_nmos W=0.3u L=0.13u
MMR_30_3 RBL[3] RWL[30] MID_30_3 GND sg13_lv_nmos W=0.3u L=0.13u
MMW_30_4 WBL[4] WWL[30] SN_30_4 GND sg13_hv_nmos W=0.15u L=0.45u
MMS_30_4 MID_30_4 SN_30_4 GND GND sg13_lv_nmos W=0.3u L=0.13u
MMR_30_4 RBL[4] RWL[30] MID_30_4 GND sg13_lv_nmos W=0.3u L=0.13u
MMW_30_5 WBL[5] WWL[30] SN_30_5 GND sg13_hv_nmos W=0.15u L=0.45u
MMS_30_5 MID_30_5 SN_30_5 GND GND sg13_lv_nmos W=0.3u L=0.13u
MMR_30_5 RBL[5] RWL[30] MID_30_5 GND sg13_lv_nmos W=0.3u L=0.13u
MMW_30_6 WBL[6] WWL[30] SN_30_6 GND sg13_hv_nmos W=0.15u L=0.45u
MMS_30_6 MID_30_6 SN_30_6 GND GND sg13_lv_nmos W=0.3u L=0.13u
MMR_30_6 RBL[6] RWL[30] MID_30_6 GND sg13_lv_nmos W=0.3u L=0.13u
MMW_30_7 WBL[7] WWL[30] SN_30_7 GND sg13_hv_nmos W=0.15u L=0.45u
MMS_30_7 MID_30_7 SN_30_7 GND GND sg13_lv_nmos W=0.3u L=0.13u
MMR_30_7 RBL[7] RWL[30] MID_30_7 GND sg13_lv_nmos W=0.3u L=0.13u
MMW_30_8 WBL[8] WWL[30] SN_30_8 GND sg13_hv_nmos W=0.15u L=0.45u
MMS_30_8 MID_30_8 SN_30_8 GND GND sg13_lv_nmos W=0.3u L=0.13u
MMR_30_8 RBL[8] RWL[30] MID_30_8 GND sg13_lv_nmos W=0.3u L=0.13u
MMW_30_9 WBL[9] WWL[30] SN_30_9 GND sg13_hv_nmos W=0.15u L=0.45u
MMS_30_9 MID_30_9 SN_30_9 GND GND sg13_lv_nmos W=0.3u L=0.13u
MMR_30_9 RBL[9] RWL[30] MID_30_9 GND sg13_lv_nmos W=0.3u L=0.13u
MMW_30_10 WBL[10] WWL[30] SN_30_10 GND sg13_hv_nmos W=0.15u L=0.45u
MMS_30_10 MID_30_10 SN_30_10 GND GND sg13_lv_nmos W=0.3u L=0.13u
MMR_30_10 RBL[10] RWL[30] MID_30_10 GND sg13_lv_nmos W=0.3u L=0.13u
MMW_30_11 WBL[11] WWL[30] SN_30_11 GND sg13_hv_nmos W=0.15u L=0.45u
MMS_30_11 MID_30_11 SN_30_11 GND GND sg13_lv_nmos W=0.3u L=0.13u
MMR_30_11 RBL[11] RWL[30] MID_30_11 GND sg13_lv_nmos W=0.3u L=0.13u
MMW_30_12 WBL[12] WWL[30] SN_30_12 GND sg13_hv_nmos W=0.15u L=0.45u
MMS_30_12 MID_30_12 SN_30_12 GND GND sg13_lv_nmos W=0.3u L=0.13u
MMR_30_12 RBL[12] RWL[30] MID_30_12 GND sg13_lv_nmos W=0.3u L=0.13u
MMW_30_13 WBL[13] WWL[30] SN_30_13 GND sg13_hv_nmos W=0.15u L=0.45u
MMS_30_13 MID_30_13 SN_30_13 GND GND sg13_lv_nmos W=0.3u L=0.13u
MMR_30_13 RBL[13] RWL[30] MID_30_13 GND sg13_lv_nmos W=0.3u L=0.13u
MMW_30_14 WBL[14] WWL[30] SN_30_14 GND sg13_hv_nmos W=0.15u L=0.45u
MMS_30_14 MID_30_14 SN_30_14 GND GND sg13_lv_nmos W=0.3u L=0.13u
MMR_30_14 RBL[14] RWL[30] MID_30_14 GND sg13_lv_nmos W=0.3u L=0.13u
MMW_30_15 WBL[15] WWL[30] SN_30_15 GND sg13_hv_nmos W=0.15u L=0.45u
MMS_30_15 MID_30_15 SN_30_15 GND GND sg13_lv_nmos W=0.3u L=0.13u
MMR_30_15 RBL[15] RWL[30] MID_30_15 GND sg13_lv_nmos W=0.3u L=0.13u
MMW_30_16 WBL[16] WWL[30] SN_30_16 GND sg13_hv_nmos W=0.15u L=0.45u
MMS_30_16 MID_30_16 SN_30_16 GND GND sg13_lv_nmos W=0.3u L=0.13u
MMR_30_16 RBL[16] RWL[30] MID_30_16 GND sg13_lv_nmos W=0.3u L=0.13u
MMW_30_17 WBL[17] WWL[30] SN_30_17 GND sg13_hv_nmos W=0.15u L=0.45u
MMS_30_17 MID_30_17 SN_30_17 GND GND sg13_lv_nmos W=0.3u L=0.13u
MMR_30_17 RBL[17] RWL[30] MID_30_17 GND sg13_lv_nmos W=0.3u L=0.13u
MMW_30_18 WBL[18] WWL[30] SN_30_18 GND sg13_hv_nmos W=0.15u L=0.45u
MMS_30_18 MID_30_18 SN_30_18 GND GND sg13_lv_nmos W=0.3u L=0.13u
MMR_30_18 RBL[18] RWL[30] MID_30_18 GND sg13_lv_nmos W=0.3u L=0.13u
MMW_30_19 WBL[19] WWL[30] SN_30_19 GND sg13_hv_nmos W=0.15u L=0.45u
MMS_30_19 MID_30_19 SN_30_19 GND GND sg13_lv_nmos W=0.3u L=0.13u
MMR_30_19 RBL[19] RWL[30] MID_30_19 GND sg13_lv_nmos W=0.3u L=0.13u
MMW_30_20 WBL[20] WWL[30] SN_30_20 GND sg13_hv_nmos W=0.15u L=0.45u
MMS_30_20 MID_30_20 SN_30_20 GND GND sg13_lv_nmos W=0.3u L=0.13u
MMR_30_20 RBL[20] RWL[30] MID_30_20 GND sg13_lv_nmos W=0.3u L=0.13u
MMW_30_21 WBL[21] WWL[30] SN_30_21 GND sg13_hv_nmos W=0.15u L=0.45u
MMS_30_21 MID_30_21 SN_30_21 GND GND sg13_lv_nmos W=0.3u L=0.13u
MMR_30_21 RBL[21] RWL[30] MID_30_21 GND sg13_lv_nmos W=0.3u L=0.13u
MMW_30_22 WBL[22] WWL[30] SN_30_22 GND sg13_hv_nmos W=0.15u L=0.45u
MMS_30_22 MID_30_22 SN_30_22 GND GND sg13_lv_nmos W=0.3u L=0.13u
MMR_30_22 RBL[22] RWL[30] MID_30_22 GND sg13_lv_nmos W=0.3u L=0.13u
MMW_30_23 WBL[23] WWL[30] SN_30_23 GND sg13_hv_nmos W=0.15u L=0.45u
MMS_30_23 MID_30_23 SN_30_23 GND GND sg13_lv_nmos W=0.3u L=0.13u
MMR_30_23 RBL[23] RWL[30] MID_30_23 GND sg13_lv_nmos W=0.3u L=0.13u
MMW_30_24 WBL[24] WWL[30] SN_30_24 GND sg13_hv_nmos W=0.15u L=0.45u
MMS_30_24 MID_30_24 SN_30_24 GND GND sg13_lv_nmos W=0.3u L=0.13u
MMR_30_24 RBL[24] RWL[30] MID_30_24 GND sg13_lv_nmos W=0.3u L=0.13u
MMW_30_25 WBL[25] WWL[30] SN_30_25 GND sg13_hv_nmos W=0.15u L=0.45u
MMS_30_25 MID_30_25 SN_30_25 GND GND sg13_lv_nmos W=0.3u L=0.13u
MMR_30_25 RBL[25] RWL[30] MID_30_25 GND sg13_lv_nmos W=0.3u L=0.13u
MMW_30_26 WBL[26] WWL[30] SN_30_26 GND sg13_hv_nmos W=0.15u L=0.45u
MMS_30_26 MID_30_26 SN_30_26 GND GND sg13_lv_nmos W=0.3u L=0.13u
MMR_30_26 RBL[26] RWL[30] MID_30_26 GND sg13_lv_nmos W=0.3u L=0.13u
MMW_30_27 WBL[27] WWL[30] SN_30_27 GND sg13_hv_nmos W=0.15u L=0.45u
MMS_30_27 MID_30_27 SN_30_27 GND GND sg13_lv_nmos W=0.3u L=0.13u
MMR_30_27 RBL[27] RWL[30] MID_30_27 GND sg13_lv_nmos W=0.3u L=0.13u
MMW_30_28 WBL[28] WWL[30] SN_30_28 GND sg13_hv_nmos W=0.15u L=0.45u
MMS_30_28 MID_30_28 SN_30_28 GND GND sg13_lv_nmos W=0.3u L=0.13u
MMR_30_28 RBL[28] RWL[30] MID_30_28 GND sg13_lv_nmos W=0.3u L=0.13u
MMW_30_29 WBL[29] WWL[30] SN_30_29 GND sg13_hv_nmos W=0.15u L=0.45u
MMS_30_29 MID_30_29 SN_30_29 GND GND sg13_lv_nmos W=0.3u L=0.13u
MMR_30_29 RBL[29] RWL[30] MID_30_29 GND sg13_lv_nmos W=0.3u L=0.13u
MMW_30_30 WBL[30] WWL[30] SN_30_30 GND sg13_hv_nmos W=0.15u L=0.45u
MMS_30_30 MID_30_30 SN_30_30 GND GND sg13_lv_nmos W=0.3u L=0.13u
MMR_30_30 RBL[30] RWL[30] MID_30_30 GND sg13_lv_nmos W=0.3u L=0.13u
MMW_30_31 WBL[31] WWL[30] SN_30_31 GND sg13_hv_nmos W=0.15u L=0.45u
MMS_30_31 MID_30_31 SN_30_31 GND GND sg13_lv_nmos W=0.3u L=0.13u
MMR_30_31 RBL[31] RWL[30] MID_30_31 GND sg13_lv_nmos W=0.3u L=0.13u
MMW_30_32 WBL[32] WWL[30] SN_30_32 GND sg13_hv_nmos W=0.15u L=0.45u
MMS_30_32 MID_30_32 SN_30_32 GND GND sg13_lv_nmos W=0.3u L=0.13u
MMR_30_32 RBL[32] RWL[30] MID_30_32 GND sg13_lv_nmos W=0.3u L=0.13u
MMW_30_33 WBL[33] WWL[30] SN_30_33 GND sg13_hv_nmos W=0.15u L=0.45u
MMS_30_33 MID_30_33 SN_30_33 GND GND sg13_lv_nmos W=0.3u L=0.13u
MMR_30_33 RBL[33] RWL[30] MID_30_33 GND sg13_lv_nmos W=0.3u L=0.13u
MMW_30_34 WBL[34] WWL[30] SN_30_34 GND sg13_hv_nmos W=0.15u L=0.45u
MMS_30_34 MID_30_34 SN_30_34 GND GND sg13_lv_nmos W=0.3u L=0.13u
MMR_30_34 RBL[34] RWL[30] MID_30_34 GND sg13_lv_nmos W=0.3u L=0.13u
MMW_30_35 WBL[35] WWL[30] SN_30_35 GND sg13_hv_nmos W=0.15u L=0.45u
MMS_30_35 MID_30_35 SN_30_35 GND GND sg13_lv_nmos W=0.3u L=0.13u
MMR_30_35 RBL[35] RWL[30] MID_30_35 GND sg13_lv_nmos W=0.3u L=0.13u
MMW_30_36 WBL[36] WWL[30] SN_30_36 GND sg13_hv_nmos W=0.15u L=0.45u
MMS_30_36 MID_30_36 SN_30_36 GND GND sg13_lv_nmos W=0.3u L=0.13u
MMR_30_36 RBL[36] RWL[30] MID_30_36 GND sg13_lv_nmos W=0.3u L=0.13u
MMW_30_37 WBL[37] WWL[30] SN_30_37 GND sg13_hv_nmos W=0.15u L=0.45u
MMS_30_37 MID_30_37 SN_30_37 GND GND sg13_lv_nmos W=0.3u L=0.13u
MMR_30_37 RBL[37] RWL[30] MID_30_37 GND sg13_lv_nmos W=0.3u L=0.13u
MMW_31_0 WBL[0] WWL[31] SN_31_0 GND sg13_hv_nmos W=0.15u L=0.45u
MMS_31_0 MID_31_0 SN_31_0 GND GND sg13_lv_nmos W=0.3u L=0.13u
MMR_31_0 RBL[0] RWL[31] MID_31_0 GND sg13_lv_nmos W=0.3u L=0.13u
MMW_31_1 WBL[1] WWL[31] SN_31_1 GND sg13_hv_nmos W=0.15u L=0.45u
MMS_31_1 MID_31_1 SN_31_1 GND GND sg13_lv_nmos W=0.3u L=0.13u
MMR_31_1 RBL[1] RWL[31] MID_31_1 GND sg13_lv_nmos W=0.3u L=0.13u
MMW_31_2 WBL[2] WWL[31] SN_31_2 GND sg13_hv_nmos W=0.15u L=0.45u
MMS_31_2 MID_31_2 SN_31_2 GND GND sg13_lv_nmos W=0.3u L=0.13u
MMR_31_2 RBL[2] RWL[31] MID_31_2 GND sg13_lv_nmos W=0.3u L=0.13u
MMW_31_3 WBL[3] WWL[31] SN_31_3 GND sg13_hv_nmos W=0.15u L=0.45u
MMS_31_3 MID_31_3 SN_31_3 GND GND sg13_lv_nmos W=0.3u L=0.13u
MMR_31_3 RBL[3] RWL[31] MID_31_3 GND sg13_lv_nmos W=0.3u L=0.13u
MMW_31_4 WBL[4] WWL[31] SN_31_4 GND sg13_hv_nmos W=0.15u L=0.45u
MMS_31_4 MID_31_4 SN_31_4 GND GND sg13_lv_nmos W=0.3u L=0.13u
MMR_31_4 RBL[4] RWL[31] MID_31_4 GND sg13_lv_nmos W=0.3u L=0.13u
MMW_31_5 WBL[5] WWL[31] SN_31_5 GND sg13_hv_nmos W=0.15u L=0.45u
MMS_31_5 MID_31_5 SN_31_5 GND GND sg13_lv_nmos W=0.3u L=0.13u
MMR_31_5 RBL[5] RWL[31] MID_31_5 GND sg13_lv_nmos W=0.3u L=0.13u
MMW_31_6 WBL[6] WWL[31] SN_31_6 GND sg13_hv_nmos W=0.15u L=0.45u
MMS_31_6 MID_31_6 SN_31_6 GND GND sg13_lv_nmos W=0.3u L=0.13u
MMR_31_6 RBL[6] RWL[31] MID_31_6 GND sg13_lv_nmos W=0.3u L=0.13u
MMW_31_7 WBL[7] WWL[31] SN_31_7 GND sg13_hv_nmos W=0.15u L=0.45u
MMS_31_7 MID_31_7 SN_31_7 GND GND sg13_lv_nmos W=0.3u L=0.13u
MMR_31_7 RBL[7] RWL[31] MID_31_7 GND sg13_lv_nmos W=0.3u L=0.13u
MMW_31_8 WBL[8] WWL[31] SN_31_8 GND sg13_hv_nmos W=0.15u L=0.45u
MMS_31_8 MID_31_8 SN_31_8 GND GND sg13_lv_nmos W=0.3u L=0.13u
MMR_31_8 RBL[8] RWL[31] MID_31_8 GND sg13_lv_nmos W=0.3u L=0.13u
MMW_31_9 WBL[9] WWL[31] SN_31_9 GND sg13_hv_nmos W=0.15u L=0.45u
MMS_31_9 MID_31_9 SN_31_9 GND GND sg13_lv_nmos W=0.3u L=0.13u
MMR_31_9 RBL[9] RWL[31] MID_31_9 GND sg13_lv_nmos W=0.3u L=0.13u
MMW_31_10 WBL[10] WWL[31] SN_31_10 GND sg13_hv_nmos W=0.15u L=0.45u
MMS_31_10 MID_31_10 SN_31_10 GND GND sg13_lv_nmos W=0.3u L=0.13u
MMR_31_10 RBL[10] RWL[31] MID_31_10 GND sg13_lv_nmos W=0.3u L=0.13u
MMW_31_11 WBL[11] WWL[31] SN_31_11 GND sg13_hv_nmos W=0.15u L=0.45u
MMS_31_11 MID_31_11 SN_31_11 GND GND sg13_lv_nmos W=0.3u L=0.13u
MMR_31_11 RBL[11] RWL[31] MID_31_11 GND sg13_lv_nmos W=0.3u L=0.13u
MMW_31_12 WBL[12] WWL[31] SN_31_12 GND sg13_hv_nmos W=0.15u L=0.45u
MMS_31_12 MID_31_12 SN_31_12 GND GND sg13_lv_nmos W=0.3u L=0.13u
MMR_31_12 RBL[12] RWL[31] MID_31_12 GND sg13_lv_nmos W=0.3u L=0.13u
MMW_31_13 WBL[13] WWL[31] SN_31_13 GND sg13_hv_nmos W=0.15u L=0.45u
MMS_31_13 MID_31_13 SN_31_13 GND GND sg13_lv_nmos W=0.3u L=0.13u
MMR_31_13 RBL[13] RWL[31] MID_31_13 GND sg13_lv_nmos W=0.3u L=0.13u
MMW_31_14 WBL[14] WWL[31] SN_31_14 GND sg13_hv_nmos W=0.15u L=0.45u
MMS_31_14 MID_31_14 SN_31_14 GND GND sg13_lv_nmos W=0.3u L=0.13u
MMR_31_14 RBL[14] RWL[31] MID_31_14 GND sg13_lv_nmos W=0.3u L=0.13u
MMW_31_15 WBL[15] WWL[31] SN_31_15 GND sg13_hv_nmos W=0.15u L=0.45u
MMS_31_15 MID_31_15 SN_31_15 GND GND sg13_lv_nmos W=0.3u L=0.13u
MMR_31_15 RBL[15] RWL[31] MID_31_15 GND sg13_lv_nmos W=0.3u L=0.13u
MMW_31_16 WBL[16] WWL[31] SN_31_16 GND sg13_hv_nmos W=0.15u L=0.45u
MMS_31_16 MID_31_16 SN_31_16 GND GND sg13_lv_nmos W=0.3u L=0.13u
MMR_31_16 RBL[16] RWL[31] MID_31_16 GND sg13_lv_nmos W=0.3u L=0.13u
MMW_31_17 WBL[17] WWL[31] SN_31_17 GND sg13_hv_nmos W=0.15u L=0.45u
MMS_31_17 MID_31_17 SN_31_17 GND GND sg13_lv_nmos W=0.3u L=0.13u
MMR_31_17 RBL[17] RWL[31] MID_31_17 GND sg13_lv_nmos W=0.3u L=0.13u
MMW_31_18 WBL[18] WWL[31] SN_31_18 GND sg13_hv_nmos W=0.15u L=0.45u
MMS_31_18 MID_31_18 SN_31_18 GND GND sg13_lv_nmos W=0.3u L=0.13u
MMR_31_18 RBL[18] RWL[31] MID_31_18 GND sg13_lv_nmos W=0.3u L=0.13u
MMW_31_19 WBL[19] WWL[31] SN_31_19 GND sg13_hv_nmos W=0.15u L=0.45u
MMS_31_19 MID_31_19 SN_31_19 GND GND sg13_lv_nmos W=0.3u L=0.13u
MMR_31_19 RBL[19] RWL[31] MID_31_19 GND sg13_lv_nmos W=0.3u L=0.13u
MMW_31_20 WBL[20] WWL[31] SN_31_20 GND sg13_hv_nmos W=0.15u L=0.45u
MMS_31_20 MID_31_20 SN_31_20 GND GND sg13_lv_nmos W=0.3u L=0.13u
MMR_31_20 RBL[20] RWL[31] MID_31_20 GND sg13_lv_nmos W=0.3u L=0.13u
MMW_31_21 WBL[21] WWL[31] SN_31_21 GND sg13_hv_nmos W=0.15u L=0.45u
MMS_31_21 MID_31_21 SN_31_21 GND GND sg13_lv_nmos W=0.3u L=0.13u
MMR_31_21 RBL[21] RWL[31] MID_31_21 GND sg13_lv_nmos W=0.3u L=0.13u
MMW_31_22 WBL[22] WWL[31] SN_31_22 GND sg13_hv_nmos W=0.15u L=0.45u
MMS_31_22 MID_31_22 SN_31_22 GND GND sg13_lv_nmos W=0.3u L=0.13u
MMR_31_22 RBL[22] RWL[31] MID_31_22 GND sg13_lv_nmos W=0.3u L=0.13u
MMW_31_23 WBL[23] WWL[31] SN_31_23 GND sg13_hv_nmos W=0.15u L=0.45u
MMS_31_23 MID_31_23 SN_31_23 GND GND sg13_lv_nmos W=0.3u L=0.13u
MMR_31_23 RBL[23] RWL[31] MID_31_23 GND sg13_lv_nmos W=0.3u L=0.13u
MMW_31_24 WBL[24] WWL[31] SN_31_24 GND sg13_hv_nmos W=0.15u L=0.45u
MMS_31_24 MID_31_24 SN_31_24 GND GND sg13_lv_nmos W=0.3u L=0.13u
MMR_31_24 RBL[24] RWL[31] MID_31_24 GND sg13_lv_nmos W=0.3u L=0.13u
MMW_31_25 WBL[25] WWL[31] SN_31_25 GND sg13_hv_nmos W=0.15u L=0.45u
MMS_31_25 MID_31_25 SN_31_25 GND GND sg13_lv_nmos W=0.3u L=0.13u
MMR_31_25 RBL[25] RWL[31] MID_31_25 GND sg13_lv_nmos W=0.3u L=0.13u
MMW_31_26 WBL[26] WWL[31] SN_31_26 GND sg13_hv_nmos W=0.15u L=0.45u
MMS_31_26 MID_31_26 SN_31_26 GND GND sg13_lv_nmos W=0.3u L=0.13u
MMR_31_26 RBL[26] RWL[31] MID_31_26 GND sg13_lv_nmos W=0.3u L=0.13u
MMW_31_27 WBL[27] WWL[31] SN_31_27 GND sg13_hv_nmos W=0.15u L=0.45u
MMS_31_27 MID_31_27 SN_31_27 GND GND sg13_lv_nmos W=0.3u L=0.13u
MMR_31_27 RBL[27] RWL[31] MID_31_27 GND sg13_lv_nmos W=0.3u L=0.13u
MMW_31_28 WBL[28] WWL[31] SN_31_28 GND sg13_hv_nmos W=0.15u L=0.45u
MMS_31_28 MID_31_28 SN_31_28 GND GND sg13_lv_nmos W=0.3u L=0.13u
MMR_31_28 RBL[28] RWL[31] MID_31_28 GND sg13_lv_nmos W=0.3u L=0.13u
MMW_31_29 WBL[29] WWL[31] SN_31_29 GND sg13_hv_nmos W=0.15u L=0.45u
MMS_31_29 MID_31_29 SN_31_29 GND GND sg13_lv_nmos W=0.3u L=0.13u
MMR_31_29 RBL[29] RWL[31] MID_31_29 GND sg13_lv_nmos W=0.3u L=0.13u
MMW_31_30 WBL[30] WWL[31] SN_31_30 GND sg13_hv_nmos W=0.15u L=0.45u
MMS_31_30 MID_31_30 SN_31_30 GND GND sg13_lv_nmos W=0.3u L=0.13u
MMR_31_30 RBL[30] RWL[31] MID_31_30 GND sg13_lv_nmos W=0.3u L=0.13u
MMW_31_31 WBL[31] WWL[31] SN_31_31 GND sg13_hv_nmos W=0.15u L=0.45u
MMS_31_31 MID_31_31 SN_31_31 GND GND sg13_lv_nmos W=0.3u L=0.13u
MMR_31_31 RBL[31] RWL[31] MID_31_31 GND sg13_lv_nmos W=0.3u L=0.13u
MMW_31_32 WBL[32] WWL[31] SN_31_32 GND sg13_hv_nmos W=0.15u L=0.45u
MMS_31_32 MID_31_32 SN_31_32 GND GND sg13_lv_nmos W=0.3u L=0.13u
MMR_31_32 RBL[32] RWL[31] MID_31_32 GND sg13_lv_nmos W=0.3u L=0.13u
MMW_31_33 WBL[33] WWL[31] SN_31_33 GND sg13_hv_nmos W=0.15u L=0.45u
MMS_31_33 MID_31_33 SN_31_33 GND GND sg13_lv_nmos W=0.3u L=0.13u
MMR_31_33 RBL[33] RWL[31] MID_31_33 GND sg13_lv_nmos W=0.3u L=0.13u
MMW_31_34 WBL[34] WWL[31] SN_31_34 GND sg13_hv_nmos W=0.15u L=0.45u
MMS_31_34 MID_31_34 SN_31_34 GND GND sg13_lv_nmos W=0.3u L=0.13u
MMR_31_34 RBL[34] RWL[31] MID_31_34 GND sg13_lv_nmos W=0.3u L=0.13u
MMW_31_35 WBL[35] WWL[31] SN_31_35 GND sg13_hv_nmos W=0.15u L=0.45u
MMS_31_35 MID_31_35 SN_31_35 GND GND sg13_lv_nmos W=0.3u L=0.13u
MMR_31_35 RBL[35] RWL[31] MID_31_35 GND sg13_lv_nmos W=0.3u L=0.13u
MMW_31_36 WBL[36] WWL[31] SN_31_36 GND sg13_hv_nmos W=0.15u L=0.45u
MMS_31_36 MID_31_36 SN_31_36 GND GND sg13_lv_nmos W=0.3u L=0.13u
MMR_31_36 RBL[36] RWL[31] MID_31_36 GND sg13_lv_nmos W=0.3u L=0.13u
MMW_31_37 WBL[37] WWL[31] SN_31_37 GND sg13_hv_nmos W=0.15u L=0.45u
MMS_31_37 MID_31_37 SN_31_37 GND GND sg13_lv_nmos W=0.3u L=0.13u
MMR_31_37 RBL[37] RWL[31] MID_31_37 GND sg13_lv_nmos W=0.3u L=0.13u
.ENDS GC_ARRAY_32x38
