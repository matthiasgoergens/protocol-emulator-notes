* Extracted by KLayout with SG13CMOS5L LVS runset on : 06/10/2026 00:19

.SUBCKT GC_ARRAY_32x38 GND RBL[0] RBL[10] RBL[11] RBL[12] RBL[13] RBL[14]
+ RBL[15] RBL[16] RBL[17] RBL[18] RBL[19] RBL[1] RBL[20] RBL[21] RBL[22]
+ RBL[23] RBL[24] RBL[25] RBL[26] RBL[27] RBL[28] RBL[29] RBL[2] RBL[30]
+ RBL[31] RBL[32] RBL[33] RBL[34] RBL[35] RBL[36] RBL[37] RBL[3] RBL[4] RBL[5]
+ RBL[6] RBL[7] RBL[8] RBL[9] RWL[0] RWL[10] RWL[11] RWL[12] RWL[13] RWL[14]
+ RWL[15] RWL[16] RWL[17] RWL[18] RWL[19] RWL[1] RWL[20] RWL[21] RWL[22]
+ RWL[23] RWL[24] RWL[25] RWL[26] RWL[27] RWL[28] RWL[29] RWL[2] RWL[30]
+ RWL[31] RWL[3] RWL[4] RWL[5] RWL[6] RWL[7] RWL[8] RWL[9] WBL[0] WBL[10]
+ WBL[11] WBL[12] WBL[13] WBL[14] WBL[15] WBL[16] WBL[17] WBL[18] WBL[19]
+ WBL[1] WBL[20] WBL[21] WBL[22] WBL[23] WBL[24] WBL[25] WBL[26] WBL[27]
+ WBL[28] WBL[29] WBL[2] WBL[30] WBL[31] WBL[32] WBL[33] WBL[34] WBL[35]
+ WBL[36] WBL[37] WBL[3] WBL[4] WBL[5] WBL[6] WBL[7] WBL[8] WBL[9] WWL[0]
+ WWL[10] WWL[11] WWL[12] WWL[13] WWL[14] WWL[15] WWL[16] WWL[17] WWL[18]
+ WWL[19] WWL[1] WWL[20] WWL[21] WWL[22] WWL[23] WWL[24] WWL[25] WWL[26]
+ WWL[27] WWL[28] WWL[29] WWL[2] WWL[30] WWL[31] WWL[3] WWL[4] WWL[5] WWL[6]
+ WWL[7] WWL[8] WWL[9]
M$1 RBL[0] RWL[0] \$81 GND sg13_lv_nmos L=0.13u W=0.3u AS=0.102p AD=0.0525p
+ PS=1.28u PD=0.65u rfmode=0
M$2 RBL[1] RWL[0] \$83 GND sg13_lv_nmos L=0.13u W=0.3u AS=0.102p AD=0.0525p
+ PS=1.28u PD=0.65u rfmode=0
M$3 RBL[2] RWL[0] \$84 GND sg13_lv_nmos L=0.13u W=0.3u AS=0.102p AD=0.0525p
+ PS=1.28u PD=0.65u rfmode=0
M$4 RBL[3] RWL[0] \$86 GND sg13_lv_nmos L=0.13u W=0.3u AS=0.102p AD=0.0525p
+ PS=1.28u PD=0.65u rfmode=0
M$5 RBL[4] RWL[0] \$88 GND sg13_lv_nmos L=0.13u W=0.3u AS=0.102p AD=0.0525p
+ PS=1.28u PD=0.65u rfmode=0
M$6 RBL[5] RWL[0] \$89 GND sg13_lv_nmos L=0.13u W=0.3u AS=0.102p AD=0.0525p
+ PS=1.28u PD=0.65u rfmode=0
M$7 RBL[6] RWL[0] \$91 GND sg13_lv_nmos L=0.13u W=0.3u AS=0.102p AD=0.0525p
+ PS=1.28u PD=0.65u rfmode=0
M$8 RBL[7] RWL[0] \$93 GND sg13_lv_nmos L=0.13u W=0.3u AS=0.102p AD=0.0525p
+ PS=1.28u PD=0.65u rfmode=0
M$9 RBL[8] RWL[0] \$95 GND sg13_lv_nmos L=0.13u W=0.3u AS=0.102p AD=0.0525p
+ PS=1.28u PD=0.65u rfmode=0
M$10 RBL[9] RWL[0] \$96 GND sg13_lv_nmos L=0.13u W=0.3u AS=0.102p AD=0.0525p
+ PS=1.28u PD=0.65u rfmode=0
M$11 RBL[10] RWL[0] \$98 GND sg13_lv_nmos L=0.13u W=0.3u AS=0.102p AD=0.0525p
+ PS=1.28u PD=0.65u rfmode=0
M$12 RBL[11] RWL[0] \$100 GND sg13_lv_nmos L=0.13u W=0.3u AS=0.102p AD=0.0525p
+ PS=1.28u PD=0.65u rfmode=0
M$13 RBL[12] RWL[0] \$101 GND sg13_lv_nmos L=0.13u W=0.3u AS=0.102p AD=0.0525p
+ PS=1.28u PD=0.65u rfmode=0
M$14 RBL[13] RWL[0] \$103 GND sg13_lv_nmos L=0.13u W=0.3u AS=0.102p AD=0.0525p
+ PS=1.28u PD=0.65u rfmode=0
M$15 RBL[14] RWL[0] \$105 GND sg13_lv_nmos L=0.13u W=0.3u AS=0.102p AD=0.0525p
+ PS=1.28u PD=0.65u rfmode=0
M$16 RBL[15] RWL[0] \$107 GND sg13_lv_nmos L=0.13u W=0.3u AS=0.102p AD=0.0525p
+ PS=1.28u PD=0.65u rfmode=0
M$17 RBL[16] RWL[0] \$108 GND sg13_lv_nmos L=0.13u W=0.3u AS=0.102p AD=0.0525p
+ PS=1.28u PD=0.65u rfmode=0
M$18 RBL[17] RWL[0] \$110 GND sg13_lv_nmos L=0.13u W=0.3u AS=0.102p AD=0.0525p
+ PS=1.28u PD=0.65u rfmode=0
M$19 RBL[18] RWL[0] \$112 GND sg13_lv_nmos L=0.13u W=0.3u AS=0.102p AD=0.0525p
+ PS=1.28u PD=0.65u rfmode=0
M$20 \$81 \$41 GND GND sg13_lv_nmos L=0.13u W=0.3u AS=0.0525p
+ AD=0.331736842105p PS=0.65u PD=2.24315789474u rfmode=0
M$21 \$83 \$42 GND GND sg13_lv_nmos L=0.13u W=0.3u AS=0.0525p
+ AD=0.331736842105p PS=0.65u PD=2.24315789474u rfmode=0
M$22 \$84 \$43 GND GND sg13_lv_nmos L=0.13u W=0.3u AS=0.0525p
+ AD=0.331736842105p PS=0.65u PD=2.24315789474u rfmode=0
M$23 \$86 \$44 GND GND sg13_lv_nmos L=0.13u W=0.3u AS=0.0525p
+ AD=0.331736842105p PS=0.65u PD=2.24315789474u rfmode=0
M$24 \$88 \$45 GND GND sg13_lv_nmos L=0.13u W=0.3u AS=0.0525p
+ AD=0.331736842105p PS=0.65u PD=2.24315789474u rfmode=0
M$25 \$89 \$46 GND GND sg13_lv_nmos L=0.13u W=0.3u AS=0.0525p
+ AD=0.331736842105p PS=0.65u PD=2.24315789474u rfmode=0
M$26 \$91 \$47 GND GND sg13_lv_nmos L=0.13u W=0.3u AS=0.0525p
+ AD=0.331736842105p PS=0.65u PD=2.24315789474u rfmode=0
M$27 \$93 \$48 GND GND sg13_lv_nmos L=0.13u W=0.3u AS=0.0525p
+ AD=0.331736842105p PS=0.65u PD=2.24315789474u rfmode=0
M$28 \$95 \$49 GND GND sg13_lv_nmos L=0.13u W=0.3u AS=0.0525p
+ AD=0.331736842105p PS=0.65u PD=2.24315789474u rfmode=0
M$29 \$96 \$50 GND GND sg13_lv_nmos L=0.13u W=0.3u AS=0.0525p
+ AD=0.331736842105p PS=0.65u PD=2.24315789474u rfmode=0
M$30 \$98 \$51 GND GND sg13_lv_nmos L=0.13u W=0.3u AS=0.0525p
+ AD=0.331736842105p PS=0.65u PD=2.24315789474u rfmode=0
M$31 \$100 \$52 GND GND sg13_lv_nmos L=0.13u W=0.3u AS=0.0525p
+ AD=0.331736842105p PS=0.65u PD=2.24315789474u rfmode=0
M$32 \$101 \$53 GND GND sg13_lv_nmos L=0.13u W=0.3u AS=0.0525p
+ AD=0.331736842105p PS=0.65u PD=2.24315789474u rfmode=0
M$33 \$103 \$54 GND GND sg13_lv_nmos L=0.13u W=0.3u AS=0.0525p
+ AD=0.331736842105p PS=0.65u PD=2.24315789474u rfmode=0
M$34 \$105 \$55 GND GND sg13_lv_nmos L=0.13u W=0.3u AS=0.0525p
+ AD=0.331736842105p PS=0.65u PD=2.24315789474u rfmode=0
M$35 \$107 \$56 GND GND sg13_lv_nmos L=0.13u W=0.3u AS=0.0525p
+ AD=0.331736842105p PS=0.65u PD=2.24315789474u rfmode=0
M$36 \$108 \$57 GND GND sg13_lv_nmos L=0.13u W=0.3u AS=0.0525p
+ AD=0.331736842105p PS=0.65u PD=2.24315789474u rfmode=0
M$37 \$110 \$58 GND GND sg13_lv_nmos L=0.13u W=0.3u AS=0.0525p
+ AD=0.331736842105p PS=0.65u PD=2.24315789474u rfmode=0
M$38 \$112 \$59 GND GND sg13_lv_nmos L=0.13u W=0.3u AS=0.0525p
+ AD=0.331736842105p PS=0.65u PD=2.24315789474u rfmode=0
M$39 RBL[19] RWL[0] \$114 GND sg13_lv_nmos L=0.13u W=0.3u AS=0.102p AD=0.0525p
+ PS=1.28u PD=0.65u rfmode=0
M$40 RBL[20] RWL[0] \$116 GND sg13_lv_nmos L=0.13u W=0.3u AS=0.102p AD=0.0525p
+ PS=1.28u PD=0.65u rfmode=0
M$41 RBL[21] RWL[0] \$117 GND sg13_lv_nmos L=0.13u W=0.3u AS=0.102p AD=0.0525p
+ PS=1.28u PD=0.65u rfmode=0
M$42 RBL[22] RWL[0] \$115 GND sg13_lv_nmos L=0.13u W=0.3u AS=0.102p AD=0.0525p
+ PS=1.28u PD=0.65u rfmode=0
M$43 RBL[23] RWL[0] \$113 GND sg13_lv_nmos L=0.13u W=0.3u AS=0.102p AD=0.0525p
+ PS=1.28u PD=0.65u rfmode=0
M$44 RBL[24] RWL[0] \$111 GND sg13_lv_nmos L=0.13u W=0.3u AS=0.102p AD=0.0525p
+ PS=1.28u PD=0.65u rfmode=0
M$45 RBL[25] RWL[0] \$109 GND sg13_lv_nmos L=0.13u W=0.3u AS=0.102p AD=0.0525p
+ PS=1.28u PD=0.65u rfmode=0
M$46 RBL[26] RWL[0] \$106 GND sg13_lv_nmos L=0.13u W=0.3u AS=0.102p AD=0.0525p
+ PS=1.28u PD=0.65u rfmode=0
M$47 RBL[27] RWL[0] \$104 GND sg13_lv_nmos L=0.13u W=0.3u AS=0.102p AD=0.0525p
+ PS=1.28u PD=0.65u rfmode=0
M$48 RBL[28] RWL[0] \$102 GND sg13_lv_nmos L=0.13u W=0.3u AS=0.102p AD=0.0525p
+ PS=1.28u PD=0.65u rfmode=0
M$49 RBL[29] RWL[0] \$99 GND sg13_lv_nmos L=0.13u W=0.3u AS=0.102p AD=0.0525p
+ PS=1.28u PD=0.65u rfmode=0
M$50 RBL[30] RWL[0] \$97 GND sg13_lv_nmos L=0.13u W=0.3u AS=0.102p AD=0.0525p
+ PS=1.28u PD=0.65u rfmode=0
M$51 RBL[31] RWL[0] \$94 GND sg13_lv_nmos L=0.13u W=0.3u AS=0.102p AD=0.0525p
+ PS=1.28u PD=0.65u rfmode=0
M$52 RBL[32] RWL[0] \$92 GND sg13_lv_nmos L=0.13u W=0.3u AS=0.102p AD=0.0525p
+ PS=1.28u PD=0.65u rfmode=0
M$53 RBL[33] RWL[0] \$90 GND sg13_lv_nmos L=0.13u W=0.3u AS=0.102p AD=0.0525p
+ PS=1.28u PD=0.65u rfmode=0
M$54 RBL[34] RWL[0] \$87 GND sg13_lv_nmos L=0.13u W=0.3u AS=0.102p AD=0.0525p
+ PS=1.28u PD=0.65u rfmode=0
M$55 RBL[35] RWL[0] \$85 GND sg13_lv_nmos L=0.13u W=0.3u AS=0.102p AD=0.0525p
+ PS=1.28u PD=0.65u rfmode=0
M$56 RBL[36] RWL[0] \$82 GND sg13_lv_nmos L=0.13u W=0.3u AS=0.102p AD=0.0525p
+ PS=1.28u PD=0.65u rfmode=0
M$57 RBL[37] RWL[0] \$80 GND sg13_lv_nmos L=0.13u W=0.3u AS=0.102p AD=0.0525p
+ PS=1.28u PD=0.65u rfmode=0
M$58 \$114 \$60 GND GND sg13_lv_nmos L=0.13u W=0.3u AS=0.0525p
+ AD=0.331736842105p PS=0.65u PD=2.24315789474u rfmode=0
M$59 \$116 \$61 GND GND sg13_lv_nmos L=0.13u W=0.3u AS=0.0525p
+ AD=0.331736842105p PS=0.65u PD=2.24315789474u rfmode=0
M$60 \$117 \$62 GND GND sg13_lv_nmos L=0.13u W=0.3u AS=0.0525p
+ AD=0.331736842105p PS=0.65u PD=2.24315789474u rfmode=0
M$61 \$115 \$63 GND GND sg13_lv_nmos L=0.13u W=0.3u AS=0.0525p
+ AD=0.331736842105p PS=0.65u PD=2.24315789474u rfmode=0
M$62 \$113 \$64 GND GND sg13_lv_nmos L=0.13u W=0.3u AS=0.0525p
+ AD=0.331736842105p PS=0.65u PD=2.24315789474u rfmode=0
M$63 \$111 \$65 GND GND sg13_lv_nmos L=0.13u W=0.3u AS=0.0525p
+ AD=0.331736842105p PS=0.65u PD=2.24315789474u rfmode=0
M$64 \$109 \$66 GND GND sg13_lv_nmos L=0.13u W=0.3u AS=0.0525p
+ AD=0.331736842105p PS=0.65u PD=2.24315789474u rfmode=0
M$65 \$106 \$67 GND GND sg13_lv_nmos L=0.13u W=0.3u AS=0.0525p
+ AD=0.331736842105p PS=0.65u PD=2.24315789474u rfmode=0
M$66 \$104 \$68 GND GND sg13_lv_nmos L=0.13u W=0.3u AS=0.0525p
+ AD=0.331736842105p PS=0.65u PD=2.24315789474u rfmode=0
M$67 \$102 \$69 GND GND sg13_lv_nmos L=0.13u W=0.3u AS=0.0525p
+ AD=0.331736842105p PS=0.65u PD=2.24315789474u rfmode=0
M$68 \$99 \$70 GND GND sg13_lv_nmos L=0.13u W=0.3u AS=0.0525p
+ AD=0.331736842105p PS=0.65u PD=2.24315789474u rfmode=0
M$69 \$97 \$71 GND GND sg13_lv_nmos L=0.13u W=0.3u AS=0.0525p
+ AD=0.331736842105p PS=0.65u PD=2.24315789474u rfmode=0
M$70 \$94 \$72 GND GND sg13_lv_nmos L=0.13u W=0.3u AS=0.0525p
+ AD=0.331736842105p PS=0.65u PD=2.24315789474u rfmode=0
M$71 \$92 \$73 GND GND sg13_lv_nmos L=0.13u W=0.3u AS=0.0525p
+ AD=0.331736842105p PS=0.65u PD=2.24315789474u rfmode=0
M$72 \$90 \$74 GND GND sg13_lv_nmos L=0.13u W=0.3u AS=0.0525p
+ AD=0.331736842105p PS=0.65u PD=2.24315789474u rfmode=0
M$73 \$87 \$75 GND GND sg13_lv_nmos L=0.13u W=0.3u AS=0.0525p
+ AD=0.331736842105p PS=0.65u PD=2.24315789474u rfmode=0
M$74 \$85 \$76 GND GND sg13_lv_nmos L=0.13u W=0.3u AS=0.0525p
+ AD=0.331736842105p PS=0.65u PD=2.24315789474u rfmode=0
M$75 \$82 \$77 GND GND sg13_lv_nmos L=0.13u W=0.3u AS=0.0525p
+ AD=0.331736842105p PS=0.65u PD=2.24315789474u rfmode=0
M$76 \$80 \$78 GND GND sg13_lv_nmos L=0.13u W=0.3u AS=0.0525p
+ AD=0.331736842105p PS=0.65u PD=2.24315789474u rfmode=0
M$77 GND \$121 \$203 GND sg13_lv_nmos L=0.13u W=0.3u AS=0.331736842105p
+ AD=0.0525p PS=2.24315789474u PD=0.65u rfmode=0
M$78 GND \$123 \$205 GND sg13_lv_nmos L=0.13u W=0.3u AS=0.331736842105p
+ AD=0.0525p PS=2.24315789474u PD=0.65u rfmode=0
M$79 GND \$124 \$207 GND sg13_lv_nmos L=0.13u W=0.3u AS=0.331736842105p
+ AD=0.0525p PS=2.24315789474u PD=0.65u rfmode=0
M$80 GND \$127 \$208 GND sg13_lv_nmos L=0.13u W=0.3u AS=0.331736842105p
+ AD=0.0525p PS=2.24315789474u PD=0.65u rfmode=0
M$81 GND \$129 \$209 GND sg13_lv_nmos L=0.13u W=0.3u AS=0.331736842105p
+ AD=0.0525p PS=2.24315789474u PD=0.65u rfmode=0
M$82 GND \$131 \$212 GND sg13_lv_nmos L=0.13u W=0.3u AS=0.331736842105p
+ AD=0.0525p PS=2.24315789474u PD=0.65u rfmode=0
M$83 GND \$132 \$213 GND sg13_lv_nmos L=0.13u W=0.3u AS=0.331736842105p
+ AD=0.0525p PS=2.24315789474u PD=0.65u rfmode=0
M$84 GND \$134 \$215 GND sg13_lv_nmos L=0.13u W=0.3u AS=0.331736842105p
+ AD=0.0525p PS=2.24315789474u PD=0.65u rfmode=0
M$85 GND \$137 \$216 GND sg13_lv_nmos L=0.13u W=0.3u AS=0.331736842105p
+ AD=0.0525p PS=2.24315789474u PD=0.65u rfmode=0
M$86 GND \$138 \$218 GND sg13_lv_nmos L=0.13u W=0.3u AS=0.331736842105p
+ AD=0.0525p PS=2.24315789474u PD=0.65u rfmode=0
M$87 GND \$140 \$220 GND sg13_lv_nmos L=0.13u W=0.3u AS=0.331736842105p
+ AD=0.0525p PS=2.24315789474u PD=0.65u rfmode=0
M$88 GND \$143 \$221 GND sg13_lv_nmos L=0.13u W=0.3u AS=0.331736842105p
+ AD=0.0525p PS=2.24315789474u PD=0.65u rfmode=0
M$89 GND \$145 \$223 GND sg13_lv_nmos L=0.13u W=0.3u AS=0.331736842105p
+ AD=0.0525p PS=2.24315789474u PD=0.65u rfmode=0
M$90 GND \$146 \$224 GND sg13_lv_nmos L=0.13u W=0.3u AS=0.331736842105p
+ AD=0.0525p PS=2.24315789474u PD=0.65u rfmode=0
M$91 GND \$148 \$226 GND sg13_lv_nmos L=0.13u W=0.3u AS=0.331736842105p
+ AD=0.0525p PS=2.24315789474u PD=0.65u rfmode=0
M$92 GND \$150 \$228 GND sg13_lv_nmos L=0.13u W=0.3u AS=0.331736842105p
+ AD=0.0525p PS=2.24315789474u PD=0.65u rfmode=0
M$93 GND \$152 \$229 GND sg13_lv_nmos L=0.13u W=0.3u AS=0.331736842105p
+ AD=0.0525p PS=2.24315789474u PD=0.65u rfmode=0
M$94 GND \$154 \$231 GND sg13_lv_nmos L=0.13u W=0.3u AS=0.331736842105p
+ AD=0.0525p PS=2.24315789474u PD=0.65u rfmode=0
M$95 GND \$157 \$232 GND sg13_lv_nmos L=0.13u W=0.3u AS=0.331736842105p
+ AD=0.0525p PS=2.24315789474u PD=0.65u rfmode=0
M$96 \$203 RWL[1] RBL[0] GND sg13_lv_nmos L=0.13u W=0.3u AS=0.0525p AD=0.057p
+ PS=0.65u PD=0.68u rfmode=0
M$97 \$205 RWL[1] RBL[1] GND sg13_lv_nmos L=0.13u W=0.3u AS=0.0525p AD=0.057p
+ PS=0.65u PD=0.68u rfmode=0
M$98 \$207 RWL[1] RBL[2] GND sg13_lv_nmos L=0.13u W=0.3u AS=0.0525p AD=0.057p
+ PS=0.65u PD=0.68u rfmode=0
M$99 \$208 RWL[1] RBL[3] GND sg13_lv_nmos L=0.13u W=0.3u AS=0.0525p AD=0.057p
+ PS=0.65u PD=0.68u rfmode=0
M$100 \$209 RWL[1] RBL[4] GND sg13_lv_nmos L=0.13u W=0.3u AS=0.0525p AD=0.057p
+ PS=0.65u PD=0.68u rfmode=0
M$101 \$212 RWL[1] RBL[5] GND sg13_lv_nmos L=0.13u W=0.3u AS=0.0525p AD=0.057p
+ PS=0.65u PD=0.68u rfmode=0
M$102 \$213 RWL[1] RBL[6] GND sg13_lv_nmos L=0.13u W=0.3u AS=0.0525p AD=0.057p
+ PS=0.65u PD=0.68u rfmode=0
M$103 \$215 RWL[1] RBL[7] GND sg13_lv_nmos L=0.13u W=0.3u AS=0.0525p AD=0.057p
+ PS=0.65u PD=0.68u rfmode=0
M$104 \$216 RWL[1] RBL[8] GND sg13_lv_nmos L=0.13u W=0.3u AS=0.0525p AD=0.057p
+ PS=0.65u PD=0.68u rfmode=0
M$105 \$218 RWL[1] RBL[9] GND sg13_lv_nmos L=0.13u W=0.3u AS=0.0525p AD=0.057p
+ PS=0.65u PD=0.68u rfmode=0
M$106 \$220 RWL[1] RBL[10] GND sg13_lv_nmos L=0.13u W=0.3u AS=0.0525p AD=0.057p
+ PS=0.65u PD=0.68u rfmode=0
M$107 \$221 RWL[1] RBL[11] GND sg13_lv_nmos L=0.13u W=0.3u AS=0.0525p AD=0.057p
+ PS=0.65u PD=0.68u rfmode=0
M$108 \$223 RWL[1] RBL[12] GND sg13_lv_nmos L=0.13u W=0.3u AS=0.0525p AD=0.057p
+ PS=0.65u PD=0.68u rfmode=0
M$109 \$224 RWL[1] RBL[13] GND sg13_lv_nmos L=0.13u W=0.3u AS=0.0525p AD=0.057p
+ PS=0.65u PD=0.68u rfmode=0
M$110 \$226 RWL[1] RBL[14] GND sg13_lv_nmos L=0.13u W=0.3u AS=0.0525p AD=0.057p
+ PS=0.65u PD=0.68u rfmode=0
M$111 \$228 RWL[1] RBL[15] GND sg13_lv_nmos L=0.13u W=0.3u AS=0.0525p AD=0.057p
+ PS=0.65u PD=0.68u rfmode=0
M$112 \$229 RWL[1] RBL[16] GND sg13_lv_nmos L=0.13u W=0.3u AS=0.0525p AD=0.057p
+ PS=0.65u PD=0.68u rfmode=0
M$113 \$231 RWL[1] RBL[17] GND sg13_lv_nmos L=0.13u W=0.3u AS=0.0525p AD=0.057p
+ PS=0.65u PD=0.68u rfmode=0
M$114 \$232 RWL[1] RBL[18] GND sg13_lv_nmos L=0.13u W=0.3u AS=0.0525p AD=0.057p
+ PS=0.65u PD=0.68u rfmode=0
M$115 RBL[0] RWL[2] \$283 GND sg13_lv_nmos L=0.13u W=0.3u AS=0.057p AD=0.0525p
+ PS=0.68u PD=0.65u rfmode=0
M$116 RBL[1] RWL[2] \$284 GND sg13_lv_nmos L=0.13u W=0.3u AS=0.057p AD=0.0525p
+ PS=0.68u PD=0.65u rfmode=0
M$117 RBL[2] RWL[2] \$285 GND sg13_lv_nmos L=0.13u W=0.3u AS=0.057p AD=0.0525p
+ PS=0.68u PD=0.65u rfmode=0
M$118 RBL[3] RWL[2] \$287 GND sg13_lv_nmos L=0.13u W=0.3u AS=0.057p AD=0.0525p
+ PS=0.68u PD=0.65u rfmode=0
M$119 RBL[4] RWL[2] \$288 GND sg13_lv_nmos L=0.13u W=0.3u AS=0.057p AD=0.0525p
+ PS=0.68u PD=0.65u rfmode=0
M$120 RBL[5] RWL[2] \$290 GND sg13_lv_nmos L=0.13u W=0.3u AS=0.057p AD=0.0525p
+ PS=0.68u PD=0.65u rfmode=0
M$121 RBL[6] RWL[2] \$292 GND sg13_lv_nmos L=0.13u W=0.3u AS=0.057p AD=0.0525p
+ PS=0.68u PD=0.65u rfmode=0
M$122 RBL[7] RWL[2] \$293 GND sg13_lv_nmos L=0.13u W=0.3u AS=0.057p AD=0.0525p
+ PS=0.68u PD=0.65u rfmode=0
M$123 RBL[8] RWL[2] \$295 GND sg13_lv_nmos L=0.13u W=0.3u AS=0.057p AD=0.0525p
+ PS=0.68u PD=0.65u rfmode=0
M$124 RBL[9] RWL[2] \$297 GND sg13_lv_nmos L=0.13u W=0.3u AS=0.057p AD=0.0525p
+ PS=0.68u PD=0.65u rfmode=0
M$125 RBL[10] RWL[2] \$298 GND sg13_lv_nmos L=0.13u W=0.3u AS=0.057p AD=0.0525p
+ PS=0.68u PD=0.65u rfmode=0
M$126 RBL[11] RWL[2] \$300 GND sg13_lv_nmos L=0.13u W=0.3u AS=0.057p AD=0.0525p
+ PS=0.68u PD=0.65u rfmode=0
M$127 RBL[12] RWL[2] \$301 GND sg13_lv_nmos L=0.13u W=0.3u AS=0.057p AD=0.0525p
+ PS=0.68u PD=0.65u rfmode=0
M$128 RBL[13] RWL[2] \$303 GND sg13_lv_nmos L=0.13u W=0.3u AS=0.057p AD=0.0525p
+ PS=0.68u PD=0.65u rfmode=0
M$129 RBL[14] RWL[2] \$305 GND sg13_lv_nmos L=0.13u W=0.3u AS=0.057p AD=0.0525p
+ PS=0.68u PD=0.65u rfmode=0
M$130 RBL[15] RWL[2] \$306 GND sg13_lv_nmos L=0.13u W=0.3u AS=0.057p AD=0.0525p
+ PS=0.68u PD=0.65u rfmode=0
M$131 RBL[16] RWL[2] \$308 GND sg13_lv_nmos L=0.13u W=0.3u AS=0.057p AD=0.0525p
+ PS=0.68u PD=0.65u rfmode=0
M$132 RBL[17] RWL[2] \$310 GND sg13_lv_nmos L=0.13u W=0.3u AS=0.057p AD=0.0525p
+ PS=0.68u PD=0.65u rfmode=0
M$133 RBL[18] RWL[2] \$311 GND sg13_lv_nmos L=0.13u W=0.3u AS=0.057p AD=0.0525p
+ PS=0.68u PD=0.65u rfmode=0
M$134 \$283 \$243 GND GND sg13_lv_nmos L=0.13u W=0.3u AS=0.0525p
+ AD=0.331736842105p PS=0.65u PD=2.24315789474u rfmode=0
M$135 \$284 \$244 GND GND sg13_lv_nmos L=0.13u W=0.3u AS=0.0525p
+ AD=0.331736842105p PS=0.65u PD=2.24315789474u rfmode=0
M$136 \$285 \$245 GND GND sg13_lv_nmos L=0.13u W=0.3u AS=0.0525p
+ AD=0.331736842105p PS=0.65u PD=2.24315789474u rfmode=0
M$137 \$287 \$246 GND GND sg13_lv_nmos L=0.13u W=0.3u AS=0.0525p
+ AD=0.331736842105p PS=0.65u PD=2.24315789474u rfmode=0
M$138 \$288 \$247 GND GND sg13_lv_nmos L=0.13u W=0.3u AS=0.0525p
+ AD=0.331736842105p PS=0.65u PD=2.24315789474u rfmode=0
M$139 \$290 \$248 GND GND sg13_lv_nmos L=0.13u W=0.3u AS=0.0525p
+ AD=0.331736842105p PS=0.65u PD=2.24315789474u rfmode=0
M$140 \$292 \$249 GND GND sg13_lv_nmos L=0.13u W=0.3u AS=0.0525p
+ AD=0.331736842105p PS=0.65u PD=2.24315789474u rfmode=0
M$141 \$293 \$250 GND GND sg13_lv_nmos L=0.13u W=0.3u AS=0.0525p
+ AD=0.331736842105p PS=0.65u PD=2.24315789474u rfmode=0
M$142 \$295 \$251 GND GND sg13_lv_nmos L=0.13u W=0.3u AS=0.0525p
+ AD=0.331736842105p PS=0.65u PD=2.24315789474u rfmode=0
M$143 \$297 \$252 GND GND sg13_lv_nmos L=0.13u W=0.3u AS=0.0525p
+ AD=0.331736842105p PS=0.65u PD=2.24315789474u rfmode=0
M$144 \$298 \$253 GND GND sg13_lv_nmos L=0.13u W=0.3u AS=0.0525p
+ AD=0.331736842105p PS=0.65u PD=2.24315789474u rfmode=0
M$145 \$300 \$254 GND GND sg13_lv_nmos L=0.13u W=0.3u AS=0.0525p
+ AD=0.331736842105p PS=0.65u PD=2.24315789474u rfmode=0
M$146 \$301 \$255 GND GND sg13_lv_nmos L=0.13u W=0.3u AS=0.0525p
+ AD=0.331736842105p PS=0.65u PD=2.24315789474u rfmode=0
M$147 \$303 \$256 GND GND sg13_lv_nmos L=0.13u W=0.3u AS=0.0525p
+ AD=0.331736842105p PS=0.65u PD=2.24315789474u rfmode=0
M$148 \$305 \$257 GND GND sg13_lv_nmos L=0.13u W=0.3u AS=0.0525p
+ AD=0.331736842105p PS=0.65u PD=2.24315789474u rfmode=0
M$149 \$306 \$258 GND GND sg13_lv_nmos L=0.13u W=0.3u AS=0.0525p
+ AD=0.331736842105p PS=0.65u PD=2.24315789474u rfmode=0
M$150 \$308 \$259 GND GND sg13_lv_nmos L=0.13u W=0.3u AS=0.0525p
+ AD=0.331736842105p PS=0.65u PD=2.24315789474u rfmode=0
M$151 \$310 \$260 GND GND sg13_lv_nmos L=0.13u W=0.3u AS=0.0525p
+ AD=0.331736842105p PS=0.65u PD=2.24315789474u rfmode=0
M$152 \$311 \$261 GND GND sg13_lv_nmos L=0.13u W=0.3u AS=0.0525p
+ AD=0.331736842105p PS=0.65u PD=2.24315789474u rfmode=0
M$153 GND \$158 \$234 GND sg13_lv_nmos L=0.13u W=0.3u AS=0.331736842105p
+ AD=0.0525p PS=2.24315789474u PD=0.65u rfmode=0
M$154 GND \$160 \$236 GND sg13_lv_nmos L=0.13u W=0.3u AS=0.331736842105p
+ AD=0.0525p PS=2.24315789474u PD=0.65u rfmode=0
M$155 GND \$162 \$238 GND sg13_lv_nmos L=0.13u W=0.3u AS=0.331736842105p
+ AD=0.0525p PS=2.24315789474u PD=0.65u rfmode=0
M$156 GND \$165 \$239 GND sg13_lv_nmos L=0.13u W=0.3u AS=0.331736842105p
+ AD=0.0525p PS=2.24315789474u PD=0.65u rfmode=0
M$157 GND \$167 \$237 GND sg13_lv_nmos L=0.13u W=0.3u AS=0.331736842105p
+ AD=0.0525p PS=2.24315789474u PD=0.65u rfmode=0
M$158 GND \$169 \$235 GND sg13_lv_nmos L=0.13u W=0.3u AS=0.331736842105p
+ AD=0.0525p PS=2.24315789474u PD=0.65u rfmode=0
M$159 GND \$170 \$233 GND sg13_lv_nmos L=0.13u W=0.3u AS=0.331736842105p
+ AD=0.0525p PS=2.24315789474u PD=0.65u rfmode=0
M$160 GND \$173 \$230 GND sg13_lv_nmos L=0.13u W=0.3u AS=0.331736842105p
+ AD=0.0525p PS=2.24315789474u PD=0.65u rfmode=0
M$161 GND \$174 \$227 GND sg13_lv_nmos L=0.13u W=0.3u AS=0.331736842105p
+ AD=0.0525p PS=2.24315789474u PD=0.65u rfmode=0
M$162 GND \$176 \$225 GND sg13_lv_nmos L=0.13u W=0.3u AS=0.331736842105p
+ AD=0.0525p PS=2.24315789474u PD=0.65u rfmode=0
M$163 GND \$179 \$222 GND sg13_lv_nmos L=0.13u W=0.3u AS=0.331736842105p
+ AD=0.0525p PS=2.24315789474u PD=0.65u rfmode=0
M$164 GND \$180 \$219 GND sg13_lv_nmos L=0.13u W=0.3u AS=0.331736842105p
+ AD=0.0525p PS=2.24315789474u PD=0.65u rfmode=0
M$165 GND \$183 \$217 GND sg13_lv_nmos L=0.13u W=0.3u AS=0.331736842105p
+ AD=0.0525p PS=2.24315789474u PD=0.65u rfmode=0
M$166 GND \$185 \$214 GND sg13_lv_nmos L=0.13u W=0.3u AS=0.331736842105p
+ AD=0.0525p PS=2.24315789474u PD=0.65u rfmode=0
M$167 GND \$186 \$211 GND sg13_lv_nmos L=0.13u W=0.3u AS=0.331736842105p
+ AD=0.0525p PS=2.24315789474u PD=0.65u rfmode=0
M$168 GND \$189 \$210 GND sg13_lv_nmos L=0.13u W=0.3u AS=0.331736842105p
+ AD=0.0525p PS=2.24315789474u PD=0.65u rfmode=0
M$169 GND \$190 \$206 GND sg13_lv_nmos L=0.13u W=0.3u AS=0.331736842105p
+ AD=0.0525p PS=2.24315789474u PD=0.65u rfmode=0
M$170 GND \$192 \$204 GND sg13_lv_nmos L=0.13u W=0.3u AS=0.331736842105p
+ AD=0.0525p PS=2.24315789474u PD=0.65u rfmode=0
M$171 GND \$195 \$202 GND sg13_lv_nmos L=0.13u W=0.3u AS=0.331736842105p
+ AD=0.0525p PS=2.24315789474u PD=0.65u rfmode=0
M$172 \$234 RWL[1] RBL[19] GND sg13_lv_nmos L=0.13u W=0.3u AS=0.0525p AD=0.057p
+ PS=0.65u PD=0.68u rfmode=0
M$173 \$236 RWL[1] RBL[20] GND sg13_lv_nmos L=0.13u W=0.3u AS=0.0525p AD=0.057p
+ PS=0.65u PD=0.68u rfmode=0
M$174 \$238 RWL[1] RBL[21] GND sg13_lv_nmos L=0.13u W=0.3u AS=0.0525p AD=0.057p
+ PS=0.65u PD=0.68u rfmode=0
M$175 \$239 RWL[1] RBL[22] GND sg13_lv_nmos L=0.13u W=0.3u AS=0.0525p AD=0.057p
+ PS=0.65u PD=0.68u rfmode=0
M$176 \$237 RWL[1] RBL[23] GND sg13_lv_nmos L=0.13u W=0.3u AS=0.0525p AD=0.057p
+ PS=0.65u PD=0.68u rfmode=0
M$177 \$235 RWL[1] RBL[24] GND sg13_lv_nmos L=0.13u W=0.3u AS=0.0525p AD=0.057p
+ PS=0.65u PD=0.68u rfmode=0
M$178 \$233 RWL[1] RBL[25] GND sg13_lv_nmos L=0.13u W=0.3u AS=0.0525p AD=0.057p
+ PS=0.65u PD=0.68u rfmode=0
M$179 \$230 RWL[1] RBL[26] GND sg13_lv_nmos L=0.13u W=0.3u AS=0.0525p AD=0.057p
+ PS=0.65u PD=0.68u rfmode=0
M$180 \$227 RWL[1] RBL[27] GND sg13_lv_nmos L=0.13u W=0.3u AS=0.0525p AD=0.057p
+ PS=0.65u PD=0.68u rfmode=0
M$181 \$225 RWL[1] RBL[28] GND sg13_lv_nmos L=0.13u W=0.3u AS=0.0525p AD=0.057p
+ PS=0.65u PD=0.68u rfmode=0
M$182 \$222 RWL[1] RBL[29] GND sg13_lv_nmos L=0.13u W=0.3u AS=0.0525p AD=0.057p
+ PS=0.65u PD=0.68u rfmode=0
M$183 \$219 RWL[1] RBL[30] GND sg13_lv_nmos L=0.13u W=0.3u AS=0.0525p AD=0.057p
+ PS=0.65u PD=0.68u rfmode=0
M$184 \$217 RWL[1] RBL[31] GND sg13_lv_nmos L=0.13u W=0.3u AS=0.0525p AD=0.057p
+ PS=0.65u PD=0.68u rfmode=0
M$185 \$214 RWL[1] RBL[32] GND sg13_lv_nmos L=0.13u W=0.3u AS=0.0525p AD=0.057p
+ PS=0.65u PD=0.68u rfmode=0
M$186 \$211 RWL[1] RBL[33] GND sg13_lv_nmos L=0.13u W=0.3u AS=0.0525p AD=0.057p
+ PS=0.65u PD=0.68u rfmode=0
M$187 \$210 RWL[1] RBL[34] GND sg13_lv_nmos L=0.13u W=0.3u AS=0.0525p AD=0.057p
+ PS=0.65u PD=0.68u rfmode=0
M$188 \$206 RWL[1] RBL[35] GND sg13_lv_nmos L=0.13u W=0.3u AS=0.0525p AD=0.057p
+ PS=0.65u PD=0.68u rfmode=0
M$189 \$204 RWL[1] RBL[36] GND sg13_lv_nmos L=0.13u W=0.3u AS=0.0525p AD=0.057p
+ PS=0.65u PD=0.68u rfmode=0
M$190 \$202 RWL[1] RBL[37] GND sg13_lv_nmos L=0.13u W=0.3u AS=0.0525p AD=0.057p
+ PS=0.65u PD=0.68u rfmode=0
M$191 RBL[19] RWL[2] \$314 GND sg13_lv_nmos L=0.13u W=0.3u AS=0.057p AD=0.0525p
+ PS=0.68u PD=0.65u rfmode=0
M$192 RBL[20] RWL[2] \$315 GND sg13_lv_nmos L=0.13u W=0.3u AS=0.057p AD=0.0525p
+ PS=0.68u PD=0.65u rfmode=0
M$193 RBL[21] RWL[2] \$317 GND sg13_lv_nmos L=0.13u W=0.3u AS=0.057p AD=0.0525p
+ PS=0.68u PD=0.65u rfmode=0
M$194 RBL[22] RWL[2] \$319 GND sg13_lv_nmos L=0.13u W=0.3u AS=0.057p AD=0.0525p
+ PS=0.68u PD=0.65u rfmode=0
M$195 RBL[23] RWL[2] \$320 GND sg13_lv_nmos L=0.13u W=0.3u AS=0.057p AD=0.0525p
+ PS=0.68u PD=0.65u rfmode=0
M$196 RBL[24] RWL[2] \$318 GND sg13_lv_nmos L=0.13u W=0.3u AS=0.057p AD=0.0525p
+ PS=0.68u PD=0.65u rfmode=0
M$197 RBL[25] RWL[2] \$316 GND sg13_lv_nmos L=0.13u W=0.3u AS=0.057p AD=0.0525p
+ PS=0.68u PD=0.65u rfmode=0
M$198 RBL[26] RWL[2] \$313 GND sg13_lv_nmos L=0.13u W=0.3u AS=0.057p AD=0.0525p
+ PS=0.68u PD=0.65u rfmode=0
M$199 RBL[27] RWL[2] \$312 GND sg13_lv_nmos L=0.13u W=0.3u AS=0.057p AD=0.0525p
+ PS=0.68u PD=0.65u rfmode=0
M$200 RBL[28] RWL[2] \$309 GND sg13_lv_nmos L=0.13u W=0.3u AS=0.057p AD=0.0525p
+ PS=0.68u PD=0.65u rfmode=0
M$201 RBL[29] RWL[2] \$307 GND sg13_lv_nmos L=0.13u W=0.3u AS=0.057p AD=0.0525p
+ PS=0.68u PD=0.65u rfmode=0
M$202 RBL[30] RWL[2] \$304 GND sg13_lv_nmos L=0.13u W=0.3u AS=0.057p AD=0.0525p
+ PS=0.68u PD=0.65u rfmode=0
M$203 RBL[31] RWL[2] \$302 GND sg13_lv_nmos L=0.13u W=0.3u AS=0.057p AD=0.0525p
+ PS=0.68u PD=0.65u rfmode=0
M$204 RBL[32] RWL[2] \$299 GND sg13_lv_nmos L=0.13u W=0.3u AS=0.057p AD=0.0525p
+ PS=0.68u PD=0.65u rfmode=0
M$205 RBL[33] RWL[2] \$296 GND sg13_lv_nmos L=0.13u W=0.3u AS=0.057p AD=0.0525p
+ PS=0.68u PD=0.65u rfmode=0
M$206 RBL[34] RWL[2] \$294 GND sg13_lv_nmos L=0.13u W=0.3u AS=0.057p AD=0.0525p
+ PS=0.68u PD=0.65u rfmode=0
M$207 RBL[35] RWL[2] \$291 GND sg13_lv_nmos L=0.13u W=0.3u AS=0.057p AD=0.0525p
+ PS=0.68u PD=0.65u rfmode=0
M$208 RBL[36] RWL[2] \$289 GND sg13_lv_nmos L=0.13u W=0.3u AS=0.057p AD=0.0525p
+ PS=0.68u PD=0.65u rfmode=0
M$209 RBL[37] RWL[2] \$286 GND sg13_lv_nmos L=0.13u W=0.3u AS=0.057p AD=0.0525p
+ PS=0.68u PD=0.65u rfmode=0
M$210 \$314 \$262 GND GND sg13_lv_nmos L=0.13u W=0.3u AS=0.0525p
+ AD=0.331736842105p PS=0.65u PD=2.24315789474u rfmode=0
M$211 \$315 \$263 GND GND sg13_lv_nmos L=0.13u W=0.3u AS=0.0525p
+ AD=0.331736842105p PS=0.65u PD=2.24315789474u rfmode=0
M$212 \$317 \$264 GND GND sg13_lv_nmos L=0.13u W=0.3u AS=0.0525p
+ AD=0.331736842105p PS=0.65u PD=2.24315789474u rfmode=0
M$213 \$319 \$265 GND GND sg13_lv_nmos L=0.13u W=0.3u AS=0.0525p
+ AD=0.331736842105p PS=0.65u PD=2.24315789474u rfmode=0
M$214 \$320 \$266 GND GND sg13_lv_nmos L=0.13u W=0.3u AS=0.0525p
+ AD=0.331736842105p PS=0.65u PD=2.24315789474u rfmode=0
M$215 \$318 \$267 GND GND sg13_lv_nmos L=0.13u W=0.3u AS=0.0525p
+ AD=0.331736842105p PS=0.65u PD=2.24315789474u rfmode=0
M$216 \$316 \$268 GND GND sg13_lv_nmos L=0.13u W=0.3u AS=0.0525p
+ AD=0.331736842105p PS=0.65u PD=2.24315789474u rfmode=0
M$217 \$313 \$269 GND GND sg13_lv_nmos L=0.13u W=0.3u AS=0.0525p
+ AD=0.331736842105p PS=0.65u PD=2.24315789474u rfmode=0
M$218 \$312 \$270 GND GND sg13_lv_nmos L=0.13u W=0.3u AS=0.0525p
+ AD=0.331736842105p PS=0.65u PD=2.24315789474u rfmode=0
M$219 \$309 \$271 GND GND sg13_lv_nmos L=0.13u W=0.3u AS=0.0525p
+ AD=0.331736842105p PS=0.65u PD=2.24315789474u rfmode=0
M$220 \$307 \$272 GND GND sg13_lv_nmos L=0.13u W=0.3u AS=0.0525p
+ AD=0.331736842105p PS=0.65u PD=2.24315789474u rfmode=0
M$221 \$304 \$273 GND GND sg13_lv_nmos L=0.13u W=0.3u AS=0.0525p
+ AD=0.331736842105p PS=0.65u PD=2.24315789474u rfmode=0
M$222 \$302 \$274 GND GND sg13_lv_nmos L=0.13u W=0.3u AS=0.0525p
+ AD=0.331736842105p PS=0.65u PD=2.24315789474u rfmode=0
M$223 \$299 \$275 GND GND sg13_lv_nmos L=0.13u W=0.3u AS=0.0525p
+ AD=0.331736842105p PS=0.65u PD=2.24315789474u rfmode=0
M$224 \$296 \$276 GND GND sg13_lv_nmos L=0.13u W=0.3u AS=0.0525p
+ AD=0.331736842105p PS=0.65u PD=2.24315789474u rfmode=0
M$225 \$294 \$277 GND GND sg13_lv_nmos L=0.13u W=0.3u AS=0.0525p
+ AD=0.331736842105p PS=0.65u PD=2.24315789474u rfmode=0
M$226 \$291 \$278 GND GND sg13_lv_nmos L=0.13u W=0.3u AS=0.0525p
+ AD=0.331736842105p PS=0.65u PD=2.24315789474u rfmode=0
M$227 \$289 \$279 GND GND sg13_lv_nmos L=0.13u W=0.3u AS=0.0525p
+ AD=0.331736842105p PS=0.65u PD=2.24315789474u rfmode=0
M$228 \$286 \$280 GND GND sg13_lv_nmos L=0.13u W=0.3u AS=0.0525p
+ AD=0.331736842105p PS=0.65u PD=2.24315789474u rfmode=0
M$229 GND \$321 \$366 GND sg13_lv_nmos L=0.13u W=0.3u AS=0.331736842105p
+ AD=0.0525p PS=2.24315789474u PD=0.65u rfmode=0
M$230 GND \$322 \$368 GND sg13_lv_nmos L=0.13u W=0.3u AS=0.331736842105p
+ AD=0.0525p PS=2.24315789474u PD=0.65u rfmode=0
M$231 GND \$323 \$370 GND sg13_lv_nmos L=0.13u W=0.3u AS=0.331736842105p
+ AD=0.0525p PS=2.24315789474u PD=0.65u rfmode=0
M$232 GND \$324 \$371 GND sg13_lv_nmos L=0.13u W=0.3u AS=0.331736842105p
+ AD=0.0525p PS=2.24315789474u PD=0.65u rfmode=0
M$233 GND \$325 \$373 GND sg13_lv_nmos L=0.13u W=0.3u AS=0.331736842105p
+ AD=0.0525p PS=2.24315789474u PD=0.65u rfmode=0
M$234 GND \$326 \$374 GND sg13_lv_nmos L=0.13u W=0.3u AS=0.331736842105p
+ AD=0.0525p PS=2.24315789474u PD=0.65u rfmode=0
M$235 GND \$327 \$376 GND sg13_lv_nmos L=0.13u W=0.3u AS=0.331736842105p
+ AD=0.0525p PS=2.24315789474u PD=0.65u rfmode=0
M$236 GND \$328 \$378 GND sg13_lv_nmos L=0.13u W=0.3u AS=0.331736842105p
+ AD=0.0525p PS=2.24315789474u PD=0.65u rfmode=0
M$237 GND \$329 \$379 GND sg13_lv_nmos L=0.13u W=0.3u AS=0.331736842105p
+ AD=0.0525p PS=2.24315789474u PD=0.65u rfmode=0
M$238 GND \$330 \$381 GND sg13_lv_nmos L=0.13u W=0.3u AS=0.331736842105p
+ AD=0.0525p PS=2.24315789474u PD=0.65u rfmode=0
M$239 GND \$331 \$382 GND sg13_lv_nmos L=0.13u W=0.3u AS=0.331736842105p
+ AD=0.0525p PS=2.24315789474u PD=0.65u rfmode=0
M$240 GND \$332 \$384 GND sg13_lv_nmos L=0.13u W=0.3u AS=0.331736842105p
+ AD=0.0525p PS=2.24315789474u PD=0.65u rfmode=0
M$241 GND \$333 \$386 GND sg13_lv_nmos L=0.13u W=0.3u AS=0.331736842105p
+ AD=0.0525p PS=2.24315789474u PD=0.65u rfmode=0
M$242 GND \$334 \$387 GND sg13_lv_nmos L=0.13u W=0.3u AS=0.331736842105p
+ AD=0.0525p PS=2.24315789474u PD=0.65u rfmode=0
M$243 GND \$335 \$389 GND sg13_lv_nmos L=0.13u W=0.3u AS=0.331736842105p
+ AD=0.0525p PS=2.24315789474u PD=0.65u rfmode=0
M$244 GND \$336 \$390 GND sg13_lv_nmos L=0.13u W=0.3u AS=0.331736842105p
+ AD=0.0525p PS=2.24315789474u PD=0.65u rfmode=0
M$245 GND \$337 \$392 GND sg13_lv_nmos L=0.13u W=0.3u AS=0.331736842105p
+ AD=0.0525p PS=2.24315789474u PD=0.65u rfmode=0
M$246 GND \$338 \$394 GND sg13_lv_nmos L=0.13u W=0.3u AS=0.331736842105p
+ AD=0.0525p PS=2.24315789474u PD=0.65u rfmode=0
M$247 GND \$339 \$395 GND sg13_lv_nmos L=0.13u W=0.3u AS=0.331736842105p
+ AD=0.0525p PS=2.24315789474u PD=0.65u rfmode=0
M$248 \$366 RWL[3] RBL[0] GND sg13_lv_nmos L=0.13u W=0.3u AS=0.0525p AD=0.057p
+ PS=0.65u PD=0.68u rfmode=0
M$249 \$368 RWL[3] RBL[1] GND sg13_lv_nmos L=0.13u W=0.3u AS=0.0525p AD=0.057p
+ PS=0.65u PD=0.68u rfmode=0
M$250 \$370 RWL[3] RBL[2] GND sg13_lv_nmos L=0.13u W=0.3u AS=0.0525p AD=0.057p
+ PS=0.65u PD=0.68u rfmode=0
M$251 \$371 RWL[3] RBL[3] GND sg13_lv_nmos L=0.13u W=0.3u AS=0.0525p AD=0.057p
+ PS=0.65u PD=0.68u rfmode=0
M$252 \$373 RWL[3] RBL[4] GND sg13_lv_nmos L=0.13u W=0.3u AS=0.0525p AD=0.057p
+ PS=0.65u PD=0.68u rfmode=0
M$253 \$374 RWL[3] RBL[5] GND sg13_lv_nmos L=0.13u W=0.3u AS=0.0525p AD=0.057p
+ PS=0.65u PD=0.68u rfmode=0
M$254 \$376 RWL[3] RBL[6] GND sg13_lv_nmos L=0.13u W=0.3u AS=0.0525p AD=0.057p
+ PS=0.65u PD=0.68u rfmode=0
M$255 \$378 RWL[3] RBL[7] GND sg13_lv_nmos L=0.13u W=0.3u AS=0.0525p AD=0.057p
+ PS=0.65u PD=0.68u rfmode=0
M$256 \$379 RWL[3] RBL[8] GND sg13_lv_nmos L=0.13u W=0.3u AS=0.0525p AD=0.057p
+ PS=0.65u PD=0.68u rfmode=0
M$257 \$381 RWL[3] RBL[9] GND sg13_lv_nmos L=0.13u W=0.3u AS=0.0525p AD=0.057p
+ PS=0.65u PD=0.68u rfmode=0
M$258 \$382 RWL[3] RBL[10] GND sg13_lv_nmos L=0.13u W=0.3u AS=0.0525p AD=0.057p
+ PS=0.65u PD=0.68u rfmode=0
M$259 \$384 RWL[3] RBL[11] GND sg13_lv_nmos L=0.13u W=0.3u AS=0.0525p AD=0.057p
+ PS=0.65u PD=0.68u rfmode=0
M$260 \$386 RWL[3] RBL[12] GND sg13_lv_nmos L=0.13u W=0.3u AS=0.0525p AD=0.057p
+ PS=0.65u PD=0.68u rfmode=0
M$261 \$387 RWL[3] RBL[13] GND sg13_lv_nmos L=0.13u W=0.3u AS=0.0525p AD=0.057p
+ PS=0.65u PD=0.68u rfmode=0
M$262 \$389 RWL[3] RBL[14] GND sg13_lv_nmos L=0.13u W=0.3u AS=0.0525p AD=0.057p
+ PS=0.65u PD=0.68u rfmode=0
M$263 \$390 RWL[3] RBL[15] GND sg13_lv_nmos L=0.13u W=0.3u AS=0.0525p AD=0.057p
+ PS=0.65u PD=0.68u rfmode=0
M$264 \$392 RWL[3] RBL[16] GND sg13_lv_nmos L=0.13u W=0.3u AS=0.0525p AD=0.057p
+ PS=0.65u PD=0.68u rfmode=0
M$265 \$394 RWL[3] RBL[17] GND sg13_lv_nmos L=0.13u W=0.3u AS=0.0525p AD=0.057p
+ PS=0.65u PD=0.68u rfmode=0
M$266 \$395 RWL[3] RBL[18] GND sg13_lv_nmos L=0.13u W=0.3u AS=0.0525p AD=0.057p
+ PS=0.65u PD=0.68u rfmode=0
M$267 RBL[0] RWL[4] \$446 GND sg13_lv_nmos L=0.13u W=0.3u AS=0.057p AD=0.0525p
+ PS=0.68u PD=0.65u rfmode=0
M$268 RBL[1] RWL[4] \$447 GND sg13_lv_nmos L=0.13u W=0.3u AS=0.057p AD=0.0525p
+ PS=0.68u PD=0.65u rfmode=0
M$269 RBL[2] RWL[4] \$448 GND sg13_lv_nmos L=0.13u W=0.3u AS=0.057p AD=0.0525p
+ PS=0.68u PD=0.65u rfmode=0
M$270 RBL[3] RWL[4] \$450 GND sg13_lv_nmos L=0.13u W=0.3u AS=0.057p AD=0.0525p
+ PS=0.68u PD=0.65u rfmode=0
M$271 RBL[4] RWL[4] \$451 GND sg13_lv_nmos L=0.13u W=0.3u AS=0.057p AD=0.0525p
+ PS=0.68u PD=0.65u rfmode=0
M$272 RBL[5] RWL[4] \$453 GND sg13_lv_nmos L=0.13u W=0.3u AS=0.057p AD=0.0525p
+ PS=0.68u PD=0.65u rfmode=0
M$273 RBL[6] RWL[4] \$455 GND sg13_lv_nmos L=0.13u W=0.3u AS=0.057p AD=0.0525p
+ PS=0.68u PD=0.65u rfmode=0
M$274 RBL[7] RWL[4] \$456 GND sg13_lv_nmos L=0.13u W=0.3u AS=0.057p AD=0.0525p
+ PS=0.68u PD=0.65u rfmode=0
M$275 RBL[8] RWL[4] \$458 GND sg13_lv_nmos L=0.13u W=0.3u AS=0.057p AD=0.0525p
+ PS=0.68u PD=0.65u rfmode=0
M$276 RBL[9] RWL[4] \$460 GND sg13_lv_nmos L=0.13u W=0.3u AS=0.057p AD=0.0525p
+ PS=0.68u PD=0.65u rfmode=0
M$277 RBL[10] RWL[4] \$462 GND sg13_lv_nmos L=0.13u W=0.3u AS=0.057p AD=0.0525p
+ PS=0.68u PD=0.65u rfmode=0
M$278 RBL[11] RWL[4] \$463 GND sg13_lv_nmos L=0.13u W=0.3u AS=0.057p AD=0.0525p
+ PS=0.68u PD=0.65u rfmode=0
M$279 RBL[12] RWL[4] \$464 GND sg13_lv_nmos L=0.13u W=0.3u AS=0.057p AD=0.0525p
+ PS=0.68u PD=0.65u rfmode=0
M$280 RBL[13] RWL[4] \$466 GND sg13_lv_nmos L=0.13u W=0.3u AS=0.057p AD=0.0525p
+ PS=0.68u PD=0.65u rfmode=0
M$281 RBL[14] RWL[4] \$468 GND sg13_lv_nmos L=0.13u W=0.3u AS=0.057p AD=0.0525p
+ PS=0.68u PD=0.65u rfmode=0
M$282 RBL[15] RWL[4] \$469 GND sg13_lv_nmos L=0.13u W=0.3u AS=0.057p AD=0.0525p
+ PS=0.68u PD=0.65u rfmode=0
M$283 RBL[16] RWL[4] \$471 GND sg13_lv_nmos L=0.13u W=0.3u AS=0.057p AD=0.0525p
+ PS=0.68u PD=0.65u rfmode=0
M$284 RBL[17] RWL[4] \$473 GND sg13_lv_nmos L=0.13u W=0.3u AS=0.057p AD=0.0525p
+ PS=0.68u PD=0.65u rfmode=0
M$285 RBL[18] RWL[4] \$474 GND sg13_lv_nmos L=0.13u W=0.3u AS=0.057p AD=0.0525p
+ PS=0.68u PD=0.65u rfmode=0
M$286 \$446 \$406 GND GND sg13_lv_nmos L=0.13u W=0.3u AS=0.0525p
+ AD=0.331736842105p PS=0.65u PD=2.24315789474u rfmode=0
M$287 \$447 \$407 GND GND sg13_lv_nmos L=0.13u W=0.3u AS=0.0525p
+ AD=0.331736842105p PS=0.65u PD=2.24315789474u rfmode=0
M$288 \$448 \$408 GND GND sg13_lv_nmos L=0.13u W=0.3u AS=0.0525p
+ AD=0.331736842105p PS=0.65u PD=2.24315789474u rfmode=0
M$289 \$450 \$409 GND GND sg13_lv_nmos L=0.13u W=0.3u AS=0.0525p
+ AD=0.331736842105p PS=0.65u PD=2.24315789474u rfmode=0
M$290 \$451 \$410 GND GND sg13_lv_nmos L=0.13u W=0.3u AS=0.0525p
+ AD=0.331736842105p PS=0.65u PD=2.24315789474u rfmode=0
M$291 \$453 \$411 GND GND sg13_lv_nmos L=0.13u W=0.3u AS=0.0525p
+ AD=0.331736842105p PS=0.65u PD=2.24315789474u rfmode=0
M$292 \$455 \$412 GND GND sg13_lv_nmos L=0.13u W=0.3u AS=0.0525p
+ AD=0.331736842105p PS=0.65u PD=2.24315789474u rfmode=0
M$293 \$456 \$413 GND GND sg13_lv_nmos L=0.13u W=0.3u AS=0.0525p
+ AD=0.331736842105p PS=0.65u PD=2.24315789474u rfmode=0
M$294 \$458 \$414 GND GND sg13_lv_nmos L=0.13u W=0.3u AS=0.0525p
+ AD=0.331736842105p PS=0.65u PD=2.24315789474u rfmode=0
M$295 \$460 \$415 GND GND sg13_lv_nmos L=0.13u W=0.3u AS=0.0525p
+ AD=0.331736842105p PS=0.65u PD=2.24315789474u rfmode=0
M$296 \$462 \$416 GND GND sg13_lv_nmos L=0.13u W=0.3u AS=0.0525p
+ AD=0.331736842105p PS=0.65u PD=2.24315789474u rfmode=0
M$297 \$463 \$417 GND GND sg13_lv_nmos L=0.13u W=0.3u AS=0.0525p
+ AD=0.331736842105p PS=0.65u PD=2.24315789474u rfmode=0
M$298 \$464 \$418 GND GND sg13_lv_nmos L=0.13u W=0.3u AS=0.0525p
+ AD=0.331736842105p PS=0.65u PD=2.24315789474u rfmode=0
M$299 \$466 \$419 GND GND sg13_lv_nmos L=0.13u W=0.3u AS=0.0525p
+ AD=0.331736842105p PS=0.65u PD=2.24315789474u rfmode=0
M$300 \$468 \$420 GND GND sg13_lv_nmos L=0.13u W=0.3u AS=0.0525p
+ AD=0.331736842105p PS=0.65u PD=2.24315789474u rfmode=0
M$301 \$469 \$421 GND GND sg13_lv_nmos L=0.13u W=0.3u AS=0.0525p
+ AD=0.331736842105p PS=0.65u PD=2.24315789474u rfmode=0
M$302 \$471 \$422 GND GND sg13_lv_nmos L=0.13u W=0.3u AS=0.0525p
+ AD=0.331736842105p PS=0.65u PD=2.24315789474u rfmode=0
M$303 \$473 \$423 GND GND sg13_lv_nmos L=0.13u W=0.3u AS=0.0525p
+ AD=0.331736842105p PS=0.65u PD=2.24315789474u rfmode=0
M$304 \$474 \$424 GND GND sg13_lv_nmos L=0.13u W=0.3u AS=0.0525p
+ AD=0.331736842105p PS=0.65u PD=2.24315789474u rfmode=0
M$305 GND \$340 \$398 GND sg13_lv_nmos L=0.13u W=0.3u AS=0.331736842105p
+ AD=0.0525p PS=2.24315789474u PD=0.65u rfmode=0
M$306 GND \$341 \$399 GND sg13_lv_nmos L=0.13u W=0.3u AS=0.331736842105p
+ AD=0.0525p PS=2.24315789474u PD=0.65u rfmode=0
M$307 GND \$342 \$401 GND sg13_lv_nmos L=0.13u W=0.3u AS=0.331736842105p
+ AD=0.0525p PS=2.24315789474u PD=0.65u rfmode=0
M$308 GND \$343 \$402 GND sg13_lv_nmos L=0.13u W=0.3u AS=0.331736842105p
+ AD=0.0525p PS=2.24315789474u PD=0.65u rfmode=0
M$309 GND \$344 \$400 GND sg13_lv_nmos L=0.13u W=0.3u AS=0.331736842105p
+ AD=0.0525p PS=2.24315789474u PD=0.65u rfmode=0
M$310 GND \$345 \$397 GND sg13_lv_nmos L=0.13u W=0.3u AS=0.331736842105p
+ AD=0.0525p PS=2.24315789474u PD=0.65u rfmode=0
M$311 GND \$346 \$396 GND sg13_lv_nmos L=0.13u W=0.3u AS=0.331736842105p
+ AD=0.0525p PS=2.24315789474u PD=0.65u rfmode=0
M$312 GND \$347 \$393 GND sg13_lv_nmos L=0.13u W=0.3u AS=0.331736842105p
+ AD=0.0525p PS=2.24315789474u PD=0.65u rfmode=0
M$313 GND \$348 \$391 GND sg13_lv_nmos L=0.13u W=0.3u AS=0.331736842105p
+ AD=0.0525p PS=2.24315789474u PD=0.65u rfmode=0
M$314 GND \$349 \$388 GND sg13_lv_nmos L=0.13u W=0.3u AS=0.331736842105p
+ AD=0.0525p PS=2.24315789474u PD=0.65u rfmode=0
M$315 GND \$350 \$385 GND sg13_lv_nmos L=0.13u W=0.3u AS=0.331736842105p
+ AD=0.0525p PS=2.24315789474u PD=0.65u rfmode=0
M$316 GND \$351 \$383 GND sg13_lv_nmos L=0.13u W=0.3u AS=0.331736842105p
+ AD=0.0525p PS=2.24315789474u PD=0.65u rfmode=0
M$317 GND \$352 \$380 GND sg13_lv_nmos L=0.13u W=0.3u AS=0.331736842105p
+ AD=0.0525p PS=2.24315789474u PD=0.65u rfmode=0
M$318 GND \$353 \$377 GND sg13_lv_nmos L=0.13u W=0.3u AS=0.331736842105p
+ AD=0.0525p PS=2.24315789474u PD=0.65u rfmode=0
M$319 GND \$354 \$375 GND sg13_lv_nmos L=0.13u W=0.3u AS=0.331736842105p
+ AD=0.0525p PS=2.24315789474u PD=0.65u rfmode=0
M$320 GND \$355 \$372 GND sg13_lv_nmos L=0.13u W=0.3u AS=0.331736842105p
+ AD=0.0525p PS=2.24315789474u PD=0.65u rfmode=0
M$321 GND \$356 \$369 GND sg13_lv_nmos L=0.13u W=0.3u AS=0.331736842105p
+ AD=0.0525p PS=2.24315789474u PD=0.65u rfmode=0
M$322 GND \$357 \$367 GND sg13_lv_nmos L=0.13u W=0.3u AS=0.331736842105p
+ AD=0.0525p PS=2.24315789474u PD=0.65u rfmode=0
M$323 GND \$358 \$365 GND sg13_lv_nmos L=0.13u W=0.3u AS=0.331736842105p
+ AD=0.0525p PS=2.24315789474u PD=0.65u rfmode=0
M$324 \$398 RWL[3] RBL[19] GND sg13_lv_nmos L=0.13u W=0.3u AS=0.0525p AD=0.057p
+ PS=0.65u PD=0.68u rfmode=0
M$325 \$399 RWL[3] RBL[20] GND sg13_lv_nmos L=0.13u W=0.3u AS=0.0525p AD=0.057p
+ PS=0.65u PD=0.68u rfmode=0
M$326 \$401 RWL[3] RBL[21] GND sg13_lv_nmos L=0.13u W=0.3u AS=0.0525p AD=0.057p
+ PS=0.65u PD=0.68u rfmode=0
M$327 \$402 RWL[3] RBL[22] GND sg13_lv_nmos L=0.13u W=0.3u AS=0.0525p AD=0.057p
+ PS=0.65u PD=0.68u rfmode=0
M$328 \$400 RWL[3] RBL[23] GND sg13_lv_nmos L=0.13u W=0.3u AS=0.0525p AD=0.057p
+ PS=0.65u PD=0.68u rfmode=0
M$329 \$397 RWL[3] RBL[24] GND sg13_lv_nmos L=0.13u W=0.3u AS=0.0525p AD=0.057p
+ PS=0.65u PD=0.68u rfmode=0
M$330 \$396 RWL[3] RBL[25] GND sg13_lv_nmos L=0.13u W=0.3u AS=0.0525p AD=0.057p
+ PS=0.65u PD=0.68u rfmode=0
M$331 \$393 RWL[3] RBL[26] GND sg13_lv_nmos L=0.13u W=0.3u AS=0.0525p AD=0.057p
+ PS=0.65u PD=0.68u rfmode=0
M$332 \$391 RWL[3] RBL[27] GND sg13_lv_nmos L=0.13u W=0.3u AS=0.0525p AD=0.057p
+ PS=0.65u PD=0.68u rfmode=0
M$333 \$388 RWL[3] RBL[28] GND sg13_lv_nmos L=0.13u W=0.3u AS=0.0525p AD=0.057p
+ PS=0.65u PD=0.68u rfmode=0
M$334 \$385 RWL[3] RBL[29] GND sg13_lv_nmos L=0.13u W=0.3u AS=0.0525p AD=0.057p
+ PS=0.65u PD=0.68u rfmode=0
M$335 \$383 RWL[3] RBL[30] GND sg13_lv_nmos L=0.13u W=0.3u AS=0.0525p AD=0.057p
+ PS=0.65u PD=0.68u rfmode=0
M$336 \$380 RWL[3] RBL[31] GND sg13_lv_nmos L=0.13u W=0.3u AS=0.0525p AD=0.057p
+ PS=0.65u PD=0.68u rfmode=0
M$337 \$377 RWL[3] RBL[32] GND sg13_lv_nmos L=0.13u W=0.3u AS=0.0525p AD=0.057p
+ PS=0.65u PD=0.68u rfmode=0
M$338 \$375 RWL[3] RBL[33] GND sg13_lv_nmos L=0.13u W=0.3u AS=0.0525p AD=0.057p
+ PS=0.65u PD=0.68u rfmode=0
M$339 \$372 RWL[3] RBL[34] GND sg13_lv_nmos L=0.13u W=0.3u AS=0.0525p AD=0.057p
+ PS=0.65u PD=0.68u rfmode=0
M$340 \$369 RWL[3] RBL[35] GND sg13_lv_nmos L=0.13u W=0.3u AS=0.0525p AD=0.057p
+ PS=0.65u PD=0.68u rfmode=0
M$341 \$367 RWL[3] RBL[36] GND sg13_lv_nmos L=0.13u W=0.3u AS=0.0525p AD=0.057p
+ PS=0.65u PD=0.68u rfmode=0
M$342 \$365 RWL[3] RBL[37] GND sg13_lv_nmos L=0.13u W=0.3u AS=0.0525p AD=0.057p
+ PS=0.65u PD=0.68u rfmode=0
M$343 RBL[19] RWL[4] \$477 GND sg13_lv_nmos L=0.13u W=0.3u AS=0.057p AD=0.0525p
+ PS=0.68u PD=0.65u rfmode=0
M$344 RBL[20] RWL[4] \$478 GND sg13_lv_nmos L=0.13u W=0.3u AS=0.057p AD=0.0525p
+ PS=0.68u PD=0.65u rfmode=0
M$345 RBL[21] RWL[4] \$480 GND sg13_lv_nmos L=0.13u W=0.3u AS=0.057p AD=0.0525p
+ PS=0.68u PD=0.65u rfmode=0
M$346 RBL[22] RWL[4] \$482 GND sg13_lv_nmos L=0.13u W=0.3u AS=0.057p AD=0.0525p
+ PS=0.68u PD=0.65u rfmode=0
M$347 RBL[23] RWL[4] \$483 GND sg13_lv_nmos L=0.13u W=0.3u AS=0.057p AD=0.0525p
+ PS=0.68u PD=0.65u rfmode=0
M$348 RBL[24] RWL[4] \$481 GND sg13_lv_nmos L=0.13u W=0.3u AS=0.057p AD=0.0525p
+ PS=0.68u PD=0.65u rfmode=0
M$349 RBL[25] RWL[4] \$479 GND sg13_lv_nmos L=0.13u W=0.3u AS=0.057p AD=0.0525p
+ PS=0.68u PD=0.65u rfmode=0
M$350 RBL[26] RWL[4] \$476 GND sg13_lv_nmos L=0.13u W=0.3u AS=0.057p AD=0.0525p
+ PS=0.68u PD=0.65u rfmode=0
M$351 RBL[27] RWL[4] \$475 GND sg13_lv_nmos L=0.13u W=0.3u AS=0.057p AD=0.0525p
+ PS=0.68u PD=0.65u rfmode=0
M$352 RBL[28] RWL[4] \$472 GND sg13_lv_nmos L=0.13u W=0.3u AS=0.057p AD=0.0525p
+ PS=0.68u PD=0.65u rfmode=0
M$353 RBL[29] RWL[4] \$470 GND sg13_lv_nmos L=0.13u W=0.3u AS=0.057p AD=0.0525p
+ PS=0.68u PD=0.65u rfmode=0
M$354 RBL[30] RWL[4] \$467 GND sg13_lv_nmos L=0.13u W=0.3u AS=0.057p AD=0.0525p
+ PS=0.68u PD=0.65u rfmode=0
M$355 RBL[31] RWL[4] \$465 GND sg13_lv_nmos L=0.13u W=0.3u AS=0.057p AD=0.0525p
+ PS=0.68u PD=0.65u rfmode=0
M$356 RBL[32] RWL[4] \$461 GND sg13_lv_nmos L=0.13u W=0.3u AS=0.057p AD=0.0525p
+ PS=0.68u PD=0.65u rfmode=0
M$357 RBL[33] RWL[4] \$459 GND sg13_lv_nmos L=0.13u W=0.3u AS=0.057p AD=0.0525p
+ PS=0.68u PD=0.65u rfmode=0
M$358 RBL[34] RWL[4] \$457 GND sg13_lv_nmos L=0.13u W=0.3u AS=0.057p AD=0.0525p
+ PS=0.68u PD=0.65u rfmode=0
M$359 RBL[35] RWL[4] \$454 GND sg13_lv_nmos L=0.13u W=0.3u AS=0.057p AD=0.0525p
+ PS=0.68u PD=0.65u rfmode=0
M$360 RBL[36] RWL[4] \$452 GND sg13_lv_nmos L=0.13u W=0.3u AS=0.057p AD=0.0525p
+ PS=0.68u PD=0.65u rfmode=0
M$361 RBL[37] RWL[4] \$449 GND sg13_lv_nmos L=0.13u W=0.3u AS=0.057p AD=0.0525p
+ PS=0.68u PD=0.65u rfmode=0
M$362 \$477 \$425 GND GND sg13_lv_nmos L=0.13u W=0.3u AS=0.0525p
+ AD=0.331736842105p PS=0.65u PD=2.24315789474u rfmode=0
M$363 \$478 \$426 GND GND sg13_lv_nmos L=0.13u W=0.3u AS=0.0525p
+ AD=0.331736842105p PS=0.65u PD=2.24315789474u rfmode=0
M$364 \$480 \$427 GND GND sg13_lv_nmos L=0.13u W=0.3u AS=0.0525p
+ AD=0.331736842105p PS=0.65u PD=2.24315789474u rfmode=0
M$365 \$482 \$428 GND GND sg13_lv_nmos L=0.13u W=0.3u AS=0.0525p
+ AD=0.331736842105p PS=0.65u PD=2.24315789474u rfmode=0
M$366 \$483 \$429 GND GND sg13_lv_nmos L=0.13u W=0.3u AS=0.0525p
+ AD=0.331736842105p PS=0.65u PD=2.24315789474u rfmode=0
M$367 \$481 \$430 GND GND sg13_lv_nmos L=0.13u W=0.3u AS=0.0525p
+ AD=0.331736842105p PS=0.65u PD=2.24315789474u rfmode=0
M$368 \$479 \$431 GND GND sg13_lv_nmos L=0.13u W=0.3u AS=0.0525p
+ AD=0.331736842105p PS=0.65u PD=2.24315789474u rfmode=0
M$369 \$476 \$432 GND GND sg13_lv_nmos L=0.13u W=0.3u AS=0.0525p
+ AD=0.331736842105p PS=0.65u PD=2.24315789474u rfmode=0
M$370 \$475 \$433 GND GND sg13_lv_nmos L=0.13u W=0.3u AS=0.0525p
+ AD=0.331736842105p PS=0.65u PD=2.24315789474u rfmode=0
M$371 \$472 \$434 GND GND sg13_lv_nmos L=0.13u W=0.3u AS=0.0525p
+ AD=0.331736842105p PS=0.65u PD=2.24315789474u rfmode=0
M$372 \$470 \$435 GND GND sg13_lv_nmos L=0.13u W=0.3u AS=0.0525p
+ AD=0.331736842105p PS=0.65u PD=2.24315789474u rfmode=0
M$373 \$467 \$436 GND GND sg13_lv_nmos L=0.13u W=0.3u AS=0.0525p
+ AD=0.331736842105p PS=0.65u PD=2.24315789474u rfmode=0
M$374 \$465 \$437 GND GND sg13_lv_nmos L=0.13u W=0.3u AS=0.0525p
+ AD=0.331736842105p PS=0.65u PD=2.24315789474u rfmode=0
M$375 \$461 \$438 GND GND sg13_lv_nmos L=0.13u W=0.3u AS=0.0525p
+ AD=0.331736842105p PS=0.65u PD=2.24315789474u rfmode=0
M$376 \$459 \$439 GND GND sg13_lv_nmos L=0.13u W=0.3u AS=0.0525p
+ AD=0.331736842105p PS=0.65u PD=2.24315789474u rfmode=0
M$377 \$457 \$440 GND GND sg13_lv_nmos L=0.13u W=0.3u AS=0.0525p
+ AD=0.331736842105p PS=0.65u PD=2.24315789474u rfmode=0
M$378 \$454 \$441 GND GND sg13_lv_nmos L=0.13u W=0.3u AS=0.0525p
+ AD=0.331736842105p PS=0.65u PD=2.24315789474u rfmode=0
M$379 \$452 \$442 GND GND sg13_lv_nmos L=0.13u W=0.3u AS=0.0525p
+ AD=0.331736842105p PS=0.65u PD=2.24315789474u rfmode=0
M$380 \$449 \$443 GND GND sg13_lv_nmos L=0.13u W=0.3u AS=0.0525p
+ AD=0.331736842105p PS=0.65u PD=2.24315789474u rfmode=0
M$381 GND \$484 \$529 GND sg13_lv_nmos L=0.13u W=0.3u AS=0.331736842105p
+ AD=0.0525p PS=2.24315789474u PD=0.65u rfmode=0
M$382 GND \$485 \$531 GND sg13_lv_nmos L=0.13u W=0.3u AS=0.331736842105p
+ AD=0.0525p PS=2.24315789474u PD=0.65u rfmode=0
M$383 GND \$486 \$533 GND sg13_lv_nmos L=0.13u W=0.3u AS=0.331736842105p
+ AD=0.0525p PS=2.24315789474u PD=0.65u rfmode=0
M$384 GND \$487 \$534 GND sg13_lv_nmos L=0.13u W=0.3u AS=0.331736842105p
+ AD=0.0525p PS=2.24315789474u PD=0.65u rfmode=0
M$385 GND \$488 \$536 GND sg13_lv_nmos L=0.13u W=0.3u AS=0.331736842105p
+ AD=0.0525p PS=2.24315789474u PD=0.65u rfmode=0
M$386 GND \$489 \$537 GND sg13_lv_nmos L=0.13u W=0.3u AS=0.331736842105p
+ AD=0.0525p PS=2.24315789474u PD=0.65u rfmode=0
M$387 GND \$490 \$539 GND sg13_lv_nmos L=0.13u W=0.3u AS=0.331736842105p
+ AD=0.0525p PS=2.24315789474u PD=0.65u rfmode=0
M$388 GND \$491 \$541 GND sg13_lv_nmos L=0.13u W=0.3u AS=0.331736842105p
+ AD=0.0525p PS=2.24315789474u PD=0.65u rfmode=0
M$389 GND \$492 \$542 GND sg13_lv_nmos L=0.13u W=0.3u AS=0.331736842105p
+ AD=0.0525p PS=2.24315789474u PD=0.65u rfmode=0
M$390 GND \$493 \$544 GND sg13_lv_nmos L=0.13u W=0.3u AS=0.331736842105p
+ AD=0.0525p PS=2.24315789474u PD=0.65u rfmode=0
M$391 GND \$494 \$546 GND sg13_lv_nmos L=0.13u W=0.3u AS=0.331736842105p
+ AD=0.0525p PS=2.24315789474u PD=0.65u rfmode=0
M$392 GND \$495 \$547 GND sg13_lv_nmos L=0.13u W=0.3u AS=0.331736842105p
+ AD=0.0525p PS=2.24315789474u PD=0.65u rfmode=0
M$393 GND \$496 \$549 GND sg13_lv_nmos L=0.13u W=0.3u AS=0.331736842105p
+ AD=0.0525p PS=2.24315789474u PD=0.65u rfmode=0
M$394 GND \$497 \$550 GND sg13_lv_nmos L=0.13u W=0.3u AS=0.331736842105p
+ AD=0.0525p PS=2.24315789474u PD=0.65u rfmode=0
M$395 GND \$498 \$552 GND sg13_lv_nmos L=0.13u W=0.3u AS=0.331736842105p
+ AD=0.0525p PS=2.24315789474u PD=0.65u rfmode=0
M$396 GND \$499 \$554 GND sg13_lv_nmos L=0.13u W=0.3u AS=0.331736842105p
+ AD=0.0525p PS=2.24315789474u PD=0.65u rfmode=0
M$397 GND \$500 \$555 GND sg13_lv_nmos L=0.13u W=0.3u AS=0.331736842105p
+ AD=0.0525p PS=2.24315789474u PD=0.65u rfmode=0
M$398 GND \$501 \$557 GND sg13_lv_nmos L=0.13u W=0.3u AS=0.331736842105p
+ AD=0.0525p PS=2.24315789474u PD=0.65u rfmode=0
M$399 GND \$502 \$558 GND sg13_lv_nmos L=0.13u W=0.3u AS=0.331736842105p
+ AD=0.0525p PS=2.24315789474u PD=0.65u rfmode=0
M$400 \$529 RWL[5] RBL[0] GND sg13_lv_nmos L=0.13u W=0.3u AS=0.0525p AD=0.057p
+ PS=0.65u PD=0.68u rfmode=0
M$401 \$531 RWL[5] RBL[1] GND sg13_lv_nmos L=0.13u W=0.3u AS=0.0525p AD=0.057p
+ PS=0.65u PD=0.68u rfmode=0
M$402 \$533 RWL[5] RBL[2] GND sg13_lv_nmos L=0.13u W=0.3u AS=0.0525p AD=0.057p
+ PS=0.65u PD=0.68u rfmode=0
M$403 \$534 RWL[5] RBL[3] GND sg13_lv_nmos L=0.13u W=0.3u AS=0.0525p AD=0.057p
+ PS=0.65u PD=0.68u rfmode=0
M$404 \$536 RWL[5] RBL[4] GND sg13_lv_nmos L=0.13u W=0.3u AS=0.0525p AD=0.057p
+ PS=0.65u PD=0.68u rfmode=0
M$405 \$537 RWL[5] RBL[5] GND sg13_lv_nmos L=0.13u W=0.3u AS=0.0525p AD=0.057p
+ PS=0.65u PD=0.68u rfmode=0
M$406 \$539 RWL[5] RBL[6] GND sg13_lv_nmos L=0.13u W=0.3u AS=0.0525p AD=0.057p
+ PS=0.65u PD=0.68u rfmode=0
M$407 \$541 RWL[5] RBL[7] GND sg13_lv_nmos L=0.13u W=0.3u AS=0.0525p AD=0.057p
+ PS=0.65u PD=0.68u rfmode=0
M$408 \$542 RWL[5] RBL[8] GND sg13_lv_nmos L=0.13u W=0.3u AS=0.0525p AD=0.057p
+ PS=0.65u PD=0.68u rfmode=0
M$409 \$544 RWL[5] RBL[9] GND sg13_lv_nmos L=0.13u W=0.3u AS=0.0525p AD=0.057p
+ PS=0.65u PD=0.68u rfmode=0
M$410 \$546 RWL[5] RBL[10] GND sg13_lv_nmos L=0.13u W=0.3u AS=0.0525p AD=0.057p
+ PS=0.65u PD=0.68u rfmode=0
M$411 \$547 RWL[5] RBL[11] GND sg13_lv_nmos L=0.13u W=0.3u AS=0.0525p AD=0.057p
+ PS=0.65u PD=0.68u rfmode=0
M$412 \$549 RWL[5] RBL[12] GND sg13_lv_nmos L=0.13u W=0.3u AS=0.0525p AD=0.057p
+ PS=0.65u PD=0.68u rfmode=0
M$413 \$550 RWL[5] RBL[13] GND sg13_lv_nmos L=0.13u W=0.3u AS=0.0525p AD=0.057p
+ PS=0.65u PD=0.68u rfmode=0
M$414 \$552 RWL[5] RBL[14] GND sg13_lv_nmos L=0.13u W=0.3u AS=0.0525p AD=0.057p
+ PS=0.65u PD=0.68u rfmode=0
M$415 \$554 RWL[5] RBL[15] GND sg13_lv_nmos L=0.13u W=0.3u AS=0.0525p AD=0.057p
+ PS=0.65u PD=0.68u rfmode=0
M$416 \$555 RWL[5] RBL[16] GND sg13_lv_nmos L=0.13u W=0.3u AS=0.0525p AD=0.057p
+ PS=0.65u PD=0.68u rfmode=0
M$417 \$557 RWL[5] RBL[17] GND sg13_lv_nmos L=0.13u W=0.3u AS=0.0525p AD=0.057p
+ PS=0.65u PD=0.68u rfmode=0
M$418 \$558 RWL[5] RBL[18] GND sg13_lv_nmos L=0.13u W=0.3u AS=0.0525p AD=0.057p
+ PS=0.65u PD=0.68u rfmode=0
M$419 RBL[0] RWL[6] \$609 GND sg13_lv_nmos L=0.13u W=0.3u AS=0.057p AD=0.0525p
+ PS=0.68u PD=0.65u rfmode=0
M$420 RBL[1] RWL[6] \$610 GND sg13_lv_nmos L=0.13u W=0.3u AS=0.057p AD=0.0525p
+ PS=0.68u PD=0.65u rfmode=0
M$421 RBL[2] RWL[6] \$612 GND sg13_lv_nmos L=0.13u W=0.3u AS=0.057p AD=0.0525p
+ PS=0.68u PD=0.65u rfmode=0
M$422 RBL[3] RWL[6] \$613 GND sg13_lv_nmos L=0.13u W=0.3u AS=0.057p AD=0.0525p
+ PS=0.68u PD=0.65u rfmode=0
M$423 RBL[4] RWL[6] \$614 GND sg13_lv_nmos L=0.13u W=0.3u AS=0.057p AD=0.0525p
+ PS=0.68u PD=0.65u rfmode=0
M$424 RBL[5] RWL[6] \$616 GND sg13_lv_nmos L=0.13u W=0.3u AS=0.057p AD=0.0525p
+ PS=0.68u PD=0.65u rfmode=0
M$425 RBL[6] RWL[6] \$618 GND sg13_lv_nmos L=0.13u W=0.3u AS=0.057p AD=0.0525p
+ PS=0.68u PD=0.65u rfmode=0
M$426 RBL[7] RWL[6] \$620 GND sg13_lv_nmos L=0.13u W=0.3u AS=0.057p AD=0.0525p
+ PS=0.68u PD=0.65u rfmode=0
M$427 RBL[8] RWL[6] \$621 GND sg13_lv_nmos L=0.13u W=0.3u AS=0.057p AD=0.0525p
+ PS=0.68u PD=0.65u rfmode=0
M$428 RBL[9] RWL[6] \$623 GND sg13_lv_nmos L=0.13u W=0.3u AS=0.057p AD=0.0525p
+ PS=0.68u PD=0.65u rfmode=0
M$429 RBL[10] RWL[6] \$624 GND sg13_lv_nmos L=0.13u W=0.3u AS=0.057p AD=0.0525p
+ PS=0.68u PD=0.65u rfmode=0
M$430 RBL[11] RWL[6] \$626 GND sg13_lv_nmos L=0.13u W=0.3u AS=0.057p AD=0.0525p
+ PS=0.68u PD=0.65u rfmode=0
M$431 RBL[12] RWL[6] \$628 GND sg13_lv_nmos L=0.13u W=0.3u AS=0.057p AD=0.0525p
+ PS=0.68u PD=0.65u rfmode=0
M$432 RBL[13] RWL[6] \$629 GND sg13_lv_nmos L=0.13u W=0.3u AS=0.057p AD=0.0525p
+ PS=0.68u PD=0.65u rfmode=0
M$433 RBL[14] RWL[6] \$631 GND sg13_lv_nmos L=0.13u W=0.3u AS=0.057p AD=0.0525p
+ PS=0.68u PD=0.65u rfmode=0
M$434 RBL[15] RWL[6] \$632 GND sg13_lv_nmos L=0.13u W=0.3u AS=0.057p AD=0.0525p
+ PS=0.68u PD=0.65u rfmode=0
M$435 RBL[16] RWL[6] \$634 GND sg13_lv_nmos L=0.13u W=0.3u AS=0.057p AD=0.0525p
+ PS=0.68u PD=0.65u rfmode=0
M$436 RBL[17] RWL[6] \$636 GND sg13_lv_nmos L=0.13u W=0.3u AS=0.057p AD=0.0525p
+ PS=0.68u PD=0.65u rfmode=0
M$437 RBL[18] RWL[6] \$637 GND sg13_lv_nmos L=0.13u W=0.3u AS=0.057p AD=0.0525p
+ PS=0.68u PD=0.65u rfmode=0
M$438 \$609 \$569 GND GND sg13_lv_nmos L=0.13u W=0.3u AS=0.0525p
+ AD=0.331736842105p PS=0.65u PD=2.24315789474u rfmode=0
M$439 \$610 \$570 GND GND sg13_lv_nmos L=0.13u W=0.3u AS=0.0525p
+ AD=0.331736842105p PS=0.65u PD=2.24315789474u rfmode=0
M$440 \$612 \$571 GND GND sg13_lv_nmos L=0.13u W=0.3u AS=0.0525p
+ AD=0.331736842105p PS=0.65u PD=2.24315789474u rfmode=0
M$441 \$613 \$572 GND GND sg13_lv_nmos L=0.13u W=0.3u AS=0.0525p
+ AD=0.331736842105p PS=0.65u PD=2.24315789474u rfmode=0
M$442 \$614 \$573 GND GND sg13_lv_nmos L=0.13u W=0.3u AS=0.0525p
+ AD=0.331736842105p PS=0.65u PD=2.24315789474u rfmode=0
M$443 \$616 \$574 GND GND sg13_lv_nmos L=0.13u W=0.3u AS=0.0525p
+ AD=0.331736842105p PS=0.65u PD=2.24315789474u rfmode=0
M$444 \$618 \$575 GND GND sg13_lv_nmos L=0.13u W=0.3u AS=0.0525p
+ AD=0.331736842105p PS=0.65u PD=2.24315789474u rfmode=0
M$445 \$620 \$576 GND GND sg13_lv_nmos L=0.13u W=0.3u AS=0.0525p
+ AD=0.331736842105p PS=0.65u PD=2.24315789474u rfmode=0
M$446 \$621 \$577 GND GND sg13_lv_nmos L=0.13u W=0.3u AS=0.0525p
+ AD=0.331736842105p PS=0.65u PD=2.24315789474u rfmode=0
M$447 \$623 \$578 GND GND sg13_lv_nmos L=0.13u W=0.3u AS=0.0525p
+ AD=0.331736842105p PS=0.65u PD=2.24315789474u rfmode=0
M$448 \$624 \$579 GND GND sg13_lv_nmos L=0.13u W=0.3u AS=0.0525p
+ AD=0.331736842105p PS=0.65u PD=2.24315789474u rfmode=0
M$449 \$626 \$580 GND GND sg13_lv_nmos L=0.13u W=0.3u AS=0.0525p
+ AD=0.331736842105p PS=0.65u PD=2.24315789474u rfmode=0
M$450 \$628 \$581 GND GND sg13_lv_nmos L=0.13u W=0.3u AS=0.0525p
+ AD=0.331736842105p PS=0.65u PD=2.24315789474u rfmode=0
M$451 \$629 \$582 GND GND sg13_lv_nmos L=0.13u W=0.3u AS=0.0525p
+ AD=0.331736842105p PS=0.65u PD=2.24315789474u rfmode=0
M$452 \$631 \$583 GND GND sg13_lv_nmos L=0.13u W=0.3u AS=0.0525p
+ AD=0.331736842105p PS=0.65u PD=2.24315789474u rfmode=0
M$453 \$632 \$584 GND GND sg13_lv_nmos L=0.13u W=0.3u AS=0.0525p
+ AD=0.331736842105p PS=0.65u PD=2.24315789474u rfmode=0
M$454 \$634 \$585 GND GND sg13_lv_nmos L=0.13u W=0.3u AS=0.0525p
+ AD=0.331736842105p PS=0.65u PD=2.24315789474u rfmode=0
M$455 \$636 \$586 GND GND sg13_lv_nmos L=0.13u W=0.3u AS=0.0525p
+ AD=0.331736842105p PS=0.65u PD=2.24315789474u rfmode=0
M$456 \$637 \$587 GND GND sg13_lv_nmos L=0.13u W=0.3u AS=0.0525p
+ AD=0.331736842105p PS=0.65u PD=2.24315789474u rfmode=0
M$457 GND \$503 \$561 GND sg13_lv_nmos L=0.13u W=0.3u AS=0.331736842105p
+ AD=0.0525p PS=2.24315789474u PD=0.65u rfmode=0
M$458 GND \$504 \$562 GND sg13_lv_nmos L=0.13u W=0.3u AS=0.331736842105p
+ AD=0.0525p PS=2.24315789474u PD=0.65u rfmode=0
M$459 GND \$505 \$564 GND sg13_lv_nmos L=0.13u W=0.3u AS=0.331736842105p
+ AD=0.0525p PS=2.24315789474u PD=0.65u rfmode=0
M$460 GND \$506 \$565 GND sg13_lv_nmos L=0.13u W=0.3u AS=0.331736842105p
+ AD=0.0525p PS=2.24315789474u PD=0.65u rfmode=0
M$461 GND \$507 \$563 GND sg13_lv_nmos L=0.13u W=0.3u AS=0.331736842105p
+ AD=0.0525p PS=2.24315789474u PD=0.65u rfmode=0
M$462 GND \$508 \$560 GND sg13_lv_nmos L=0.13u W=0.3u AS=0.331736842105p
+ AD=0.0525p PS=2.24315789474u PD=0.65u rfmode=0
M$463 GND \$509 \$559 GND sg13_lv_nmos L=0.13u W=0.3u AS=0.331736842105p
+ AD=0.0525p PS=2.24315789474u PD=0.65u rfmode=0
M$464 GND \$510 \$556 GND sg13_lv_nmos L=0.13u W=0.3u AS=0.331736842105p
+ AD=0.0525p PS=2.24315789474u PD=0.65u rfmode=0
M$465 GND \$511 \$553 GND sg13_lv_nmos L=0.13u W=0.3u AS=0.331736842105p
+ AD=0.0525p PS=2.24315789474u PD=0.65u rfmode=0
M$466 GND \$512 \$551 GND sg13_lv_nmos L=0.13u W=0.3u AS=0.331736842105p
+ AD=0.0525p PS=2.24315789474u PD=0.65u rfmode=0
M$467 GND \$513 \$548 GND sg13_lv_nmos L=0.13u W=0.3u AS=0.331736842105p
+ AD=0.0525p PS=2.24315789474u PD=0.65u rfmode=0
M$468 GND \$514 \$545 GND sg13_lv_nmos L=0.13u W=0.3u AS=0.331736842105p
+ AD=0.0525p PS=2.24315789474u PD=0.65u rfmode=0
M$469 GND \$515 \$543 GND sg13_lv_nmos L=0.13u W=0.3u AS=0.331736842105p
+ AD=0.0525p PS=2.24315789474u PD=0.65u rfmode=0
M$470 GND \$516 \$540 GND sg13_lv_nmos L=0.13u W=0.3u AS=0.331736842105p
+ AD=0.0525p PS=2.24315789474u PD=0.65u rfmode=0
M$471 GND \$517 \$538 GND sg13_lv_nmos L=0.13u W=0.3u AS=0.331736842105p
+ AD=0.0525p PS=2.24315789474u PD=0.65u rfmode=0
M$472 GND \$518 \$535 GND sg13_lv_nmos L=0.13u W=0.3u AS=0.331736842105p
+ AD=0.0525p PS=2.24315789474u PD=0.65u rfmode=0
M$473 GND \$519 \$532 GND sg13_lv_nmos L=0.13u W=0.3u AS=0.331736842105p
+ AD=0.0525p PS=2.24315789474u PD=0.65u rfmode=0
M$474 GND \$520 \$530 GND sg13_lv_nmos L=0.13u W=0.3u AS=0.331736842105p
+ AD=0.0525p PS=2.24315789474u PD=0.65u rfmode=0
M$475 GND \$521 \$528 GND sg13_lv_nmos L=0.13u W=0.3u AS=0.331736842105p
+ AD=0.0525p PS=2.24315789474u PD=0.65u rfmode=0
M$476 \$561 RWL[5] RBL[19] GND sg13_lv_nmos L=0.13u W=0.3u AS=0.0525p AD=0.057p
+ PS=0.65u PD=0.68u rfmode=0
M$477 \$562 RWL[5] RBL[20] GND sg13_lv_nmos L=0.13u W=0.3u AS=0.0525p AD=0.057p
+ PS=0.65u PD=0.68u rfmode=0
M$478 \$564 RWL[5] RBL[21] GND sg13_lv_nmos L=0.13u W=0.3u AS=0.0525p AD=0.057p
+ PS=0.65u PD=0.68u rfmode=0
M$479 \$565 RWL[5] RBL[22] GND sg13_lv_nmos L=0.13u W=0.3u AS=0.0525p AD=0.057p
+ PS=0.65u PD=0.68u rfmode=0
M$480 \$563 RWL[5] RBL[23] GND sg13_lv_nmos L=0.13u W=0.3u AS=0.0525p AD=0.057p
+ PS=0.65u PD=0.68u rfmode=0
M$481 \$560 RWL[5] RBL[24] GND sg13_lv_nmos L=0.13u W=0.3u AS=0.0525p AD=0.057p
+ PS=0.65u PD=0.68u rfmode=0
M$482 \$559 RWL[5] RBL[25] GND sg13_lv_nmos L=0.13u W=0.3u AS=0.0525p AD=0.057p
+ PS=0.65u PD=0.68u rfmode=0
M$483 \$556 RWL[5] RBL[26] GND sg13_lv_nmos L=0.13u W=0.3u AS=0.0525p AD=0.057p
+ PS=0.65u PD=0.68u rfmode=0
M$484 \$553 RWL[5] RBL[27] GND sg13_lv_nmos L=0.13u W=0.3u AS=0.0525p AD=0.057p
+ PS=0.65u PD=0.68u rfmode=0
M$485 \$551 RWL[5] RBL[28] GND sg13_lv_nmos L=0.13u W=0.3u AS=0.0525p AD=0.057p
+ PS=0.65u PD=0.68u rfmode=0
M$486 \$548 RWL[5] RBL[29] GND sg13_lv_nmos L=0.13u W=0.3u AS=0.0525p AD=0.057p
+ PS=0.65u PD=0.68u rfmode=0
M$487 \$545 RWL[5] RBL[30] GND sg13_lv_nmos L=0.13u W=0.3u AS=0.0525p AD=0.057p
+ PS=0.65u PD=0.68u rfmode=0
M$488 \$543 RWL[5] RBL[31] GND sg13_lv_nmos L=0.13u W=0.3u AS=0.0525p AD=0.057p
+ PS=0.65u PD=0.68u rfmode=0
M$489 \$540 RWL[5] RBL[32] GND sg13_lv_nmos L=0.13u W=0.3u AS=0.0525p AD=0.057p
+ PS=0.65u PD=0.68u rfmode=0
M$490 \$538 RWL[5] RBL[33] GND sg13_lv_nmos L=0.13u W=0.3u AS=0.0525p AD=0.057p
+ PS=0.65u PD=0.68u rfmode=0
M$491 \$535 RWL[5] RBL[34] GND sg13_lv_nmos L=0.13u W=0.3u AS=0.0525p AD=0.057p
+ PS=0.65u PD=0.68u rfmode=0
M$492 \$532 RWL[5] RBL[35] GND sg13_lv_nmos L=0.13u W=0.3u AS=0.0525p AD=0.057p
+ PS=0.65u PD=0.68u rfmode=0
M$493 \$530 RWL[5] RBL[36] GND sg13_lv_nmos L=0.13u W=0.3u AS=0.0525p AD=0.057p
+ PS=0.65u PD=0.68u rfmode=0
M$494 \$528 RWL[5] RBL[37] GND sg13_lv_nmos L=0.13u W=0.3u AS=0.0525p AD=0.057p
+ PS=0.65u PD=0.68u rfmode=0
M$495 RBL[19] RWL[6] \$640 GND sg13_lv_nmos L=0.13u W=0.3u AS=0.057p AD=0.0525p
+ PS=0.68u PD=0.65u rfmode=0
M$496 RBL[20] RWL[6] \$641 GND sg13_lv_nmos L=0.13u W=0.3u AS=0.057p AD=0.0525p
+ PS=0.68u PD=0.65u rfmode=0
M$497 RBL[21] RWL[6] \$643 GND sg13_lv_nmos L=0.13u W=0.3u AS=0.057p AD=0.0525p
+ PS=0.68u PD=0.65u rfmode=0
M$498 RBL[22] RWL[6] \$645 GND sg13_lv_nmos L=0.13u W=0.3u AS=0.057p AD=0.0525p
+ PS=0.68u PD=0.65u rfmode=0
M$499 RBL[23] RWL[6] \$646 GND sg13_lv_nmos L=0.13u W=0.3u AS=0.057p AD=0.0525p
+ PS=0.68u PD=0.65u rfmode=0
M$500 RBL[24] RWL[6] \$644 GND sg13_lv_nmos L=0.13u W=0.3u AS=0.057p AD=0.0525p
+ PS=0.68u PD=0.65u rfmode=0
M$501 RBL[25] RWL[6] \$642 GND sg13_lv_nmos L=0.13u W=0.3u AS=0.057p AD=0.0525p
+ PS=0.68u PD=0.65u rfmode=0
M$502 RBL[26] RWL[6] \$639 GND sg13_lv_nmos L=0.13u W=0.3u AS=0.057p AD=0.0525p
+ PS=0.68u PD=0.65u rfmode=0
M$503 RBL[27] RWL[6] \$638 GND sg13_lv_nmos L=0.13u W=0.3u AS=0.057p AD=0.0525p
+ PS=0.68u PD=0.65u rfmode=0
M$504 RBL[28] RWL[6] \$635 GND sg13_lv_nmos L=0.13u W=0.3u AS=0.057p AD=0.0525p
+ PS=0.68u PD=0.65u rfmode=0
M$505 RBL[29] RWL[6] \$633 GND sg13_lv_nmos L=0.13u W=0.3u AS=0.057p AD=0.0525p
+ PS=0.68u PD=0.65u rfmode=0
M$506 RBL[30] RWL[6] \$630 GND sg13_lv_nmos L=0.13u W=0.3u AS=0.057p AD=0.0525p
+ PS=0.68u PD=0.65u rfmode=0
M$507 RBL[31] RWL[6] \$627 GND sg13_lv_nmos L=0.13u W=0.3u AS=0.057p AD=0.0525p
+ PS=0.68u PD=0.65u rfmode=0
M$508 RBL[32] RWL[6] \$625 GND sg13_lv_nmos L=0.13u W=0.3u AS=0.057p AD=0.0525p
+ PS=0.68u PD=0.65u rfmode=0
M$509 RBL[33] RWL[6] \$622 GND sg13_lv_nmos L=0.13u W=0.3u AS=0.057p AD=0.0525p
+ PS=0.68u PD=0.65u rfmode=0
M$510 RBL[34] RWL[6] \$619 GND sg13_lv_nmos L=0.13u W=0.3u AS=0.057p AD=0.0525p
+ PS=0.68u PD=0.65u rfmode=0
M$511 RBL[35] RWL[6] \$617 GND sg13_lv_nmos L=0.13u W=0.3u AS=0.057p AD=0.0525p
+ PS=0.68u PD=0.65u rfmode=0
M$512 RBL[36] RWL[6] \$615 GND sg13_lv_nmos L=0.13u W=0.3u AS=0.057p AD=0.0525p
+ PS=0.68u PD=0.65u rfmode=0
M$513 RBL[37] RWL[6] \$611 GND sg13_lv_nmos L=0.13u W=0.3u AS=0.057p AD=0.0525p
+ PS=0.68u PD=0.65u rfmode=0
M$514 \$640 \$588 GND GND sg13_lv_nmos L=0.13u W=0.3u AS=0.0525p
+ AD=0.331736842105p PS=0.65u PD=2.24315789474u rfmode=0
M$515 \$641 \$589 GND GND sg13_lv_nmos L=0.13u W=0.3u AS=0.0525p
+ AD=0.331736842105p PS=0.65u PD=2.24315789474u rfmode=0
M$516 \$643 \$590 GND GND sg13_lv_nmos L=0.13u W=0.3u AS=0.0525p
+ AD=0.331736842105p PS=0.65u PD=2.24315789474u rfmode=0
M$517 \$645 \$591 GND GND sg13_lv_nmos L=0.13u W=0.3u AS=0.0525p
+ AD=0.331736842105p PS=0.65u PD=2.24315789474u rfmode=0
M$518 \$646 \$592 GND GND sg13_lv_nmos L=0.13u W=0.3u AS=0.0525p
+ AD=0.331736842105p PS=0.65u PD=2.24315789474u rfmode=0
M$519 \$644 \$593 GND GND sg13_lv_nmos L=0.13u W=0.3u AS=0.0525p
+ AD=0.331736842105p PS=0.65u PD=2.24315789474u rfmode=0
M$520 \$642 \$594 GND GND sg13_lv_nmos L=0.13u W=0.3u AS=0.0525p
+ AD=0.331736842105p PS=0.65u PD=2.24315789474u rfmode=0
M$521 \$639 \$595 GND GND sg13_lv_nmos L=0.13u W=0.3u AS=0.0525p
+ AD=0.331736842105p PS=0.65u PD=2.24315789474u rfmode=0
M$522 \$638 \$596 GND GND sg13_lv_nmos L=0.13u W=0.3u AS=0.0525p
+ AD=0.331736842105p PS=0.65u PD=2.24315789474u rfmode=0
M$523 \$635 \$597 GND GND sg13_lv_nmos L=0.13u W=0.3u AS=0.0525p
+ AD=0.331736842105p PS=0.65u PD=2.24315789474u rfmode=0
M$524 \$633 \$598 GND GND sg13_lv_nmos L=0.13u W=0.3u AS=0.0525p
+ AD=0.331736842105p PS=0.65u PD=2.24315789474u rfmode=0
M$525 \$630 \$599 GND GND sg13_lv_nmos L=0.13u W=0.3u AS=0.0525p
+ AD=0.331736842105p PS=0.65u PD=2.24315789474u rfmode=0
M$526 \$627 \$600 GND GND sg13_lv_nmos L=0.13u W=0.3u AS=0.0525p
+ AD=0.331736842105p PS=0.65u PD=2.24315789474u rfmode=0
M$527 \$625 \$601 GND GND sg13_lv_nmos L=0.13u W=0.3u AS=0.0525p
+ AD=0.331736842105p PS=0.65u PD=2.24315789474u rfmode=0
M$528 \$622 \$602 GND GND sg13_lv_nmos L=0.13u W=0.3u AS=0.0525p
+ AD=0.331736842105p PS=0.65u PD=2.24315789474u rfmode=0
M$529 \$619 \$603 GND GND sg13_lv_nmos L=0.13u W=0.3u AS=0.0525p
+ AD=0.331736842105p PS=0.65u PD=2.24315789474u rfmode=0
M$530 \$617 \$604 GND GND sg13_lv_nmos L=0.13u W=0.3u AS=0.0525p
+ AD=0.331736842105p PS=0.65u PD=2.24315789474u rfmode=0
M$531 \$615 \$605 GND GND sg13_lv_nmos L=0.13u W=0.3u AS=0.0525p
+ AD=0.331736842105p PS=0.65u PD=2.24315789474u rfmode=0
M$532 \$611 \$606 GND GND sg13_lv_nmos L=0.13u W=0.3u AS=0.0525p
+ AD=0.331736842105p PS=0.65u PD=2.24315789474u rfmode=0
M$533 GND \$647 \$692 GND sg13_lv_nmos L=0.13u W=0.3u AS=0.331736842105p
+ AD=0.0525p PS=2.24315789474u PD=0.65u rfmode=0
M$534 GND \$648 \$694 GND sg13_lv_nmos L=0.13u W=0.3u AS=0.331736842105p
+ AD=0.0525p PS=2.24315789474u PD=0.65u rfmode=0
M$535 GND \$649 \$696 GND sg13_lv_nmos L=0.13u W=0.3u AS=0.331736842105p
+ AD=0.0525p PS=2.24315789474u PD=0.65u rfmode=0
M$536 GND \$650 \$697 GND sg13_lv_nmos L=0.13u W=0.3u AS=0.331736842105p
+ AD=0.0525p PS=2.24315789474u PD=0.65u rfmode=0
M$537 GND \$651 \$698 GND sg13_lv_nmos L=0.13u W=0.3u AS=0.331736842105p
+ AD=0.0525p PS=2.24315789474u PD=0.65u rfmode=0
M$538 GND \$652 \$700 GND sg13_lv_nmos L=0.13u W=0.3u AS=0.331736842105p
+ AD=0.0525p PS=2.24315789474u PD=0.65u rfmode=0
M$539 GND \$653 \$702 GND sg13_lv_nmos L=0.13u W=0.3u AS=0.331736842105p
+ AD=0.0525p PS=2.24315789474u PD=0.65u rfmode=0
M$540 GND \$654 \$704 GND sg13_lv_nmos L=0.13u W=0.3u AS=0.331736842105p
+ AD=0.0525p PS=2.24315789474u PD=0.65u rfmode=0
M$541 GND \$655 \$705 GND sg13_lv_nmos L=0.13u W=0.3u AS=0.331736842105p
+ AD=0.0525p PS=2.24315789474u PD=0.65u rfmode=0
M$542 GND \$656 \$707 GND sg13_lv_nmos L=0.13u W=0.3u AS=0.331736842105p
+ AD=0.0525p PS=2.24315789474u PD=0.65u rfmode=0
M$543 GND \$657 \$709 GND sg13_lv_nmos L=0.13u W=0.3u AS=0.331736842105p
+ AD=0.0525p PS=2.24315789474u PD=0.65u rfmode=0
M$544 GND \$658 \$710 GND sg13_lv_nmos L=0.13u W=0.3u AS=0.331736842105p
+ AD=0.0525p PS=2.24315789474u PD=0.65u rfmode=0
M$545 GND \$659 \$712 GND sg13_lv_nmos L=0.13u W=0.3u AS=0.331736842105p
+ AD=0.0525p PS=2.24315789474u PD=0.65u rfmode=0
M$546 GND \$660 \$713 GND sg13_lv_nmos L=0.13u W=0.3u AS=0.331736842105p
+ AD=0.0525p PS=2.24315789474u PD=0.65u rfmode=0
M$547 GND \$661 \$715 GND sg13_lv_nmos L=0.13u W=0.3u AS=0.331736842105p
+ AD=0.0525p PS=2.24315789474u PD=0.65u rfmode=0
M$548 GND \$662 \$717 GND sg13_lv_nmos L=0.13u W=0.3u AS=0.331736842105p
+ AD=0.0525p PS=2.24315789474u PD=0.65u rfmode=0
M$549 GND \$663 \$718 GND sg13_lv_nmos L=0.13u W=0.3u AS=0.331736842105p
+ AD=0.0525p PS=2.24315789474u PD=0.65u rfmode=0
M$550 GND \$664 \$720 GND sg13_lv_nmos L=0.13u W=0.3u AS=0.331736842105p
+ AD=0.0525p PS=2.24315789474u PD=0.65u rfmode=0
M$551 GND \$665 \$722 GND sg13_lv_nmos L=0.13u W=0.3u AS=0.331736842105p
+ AD=0.0525p PS=2.24315789474u PD=0.65u rfmode=0
M$552 \$692 RWL[7] RBL[0] GND sg13_lv_nmos L=0.13u W=0.3u AS=0.0525p AD=0.057p
+ PS=0.65u PD=0.68u rfmode=0
M$553 \$694 RWL[7] RBL[1] GND sg13_lv_nmos L=0.13u W=0.3u AS=0.0525p AD=0.057p
+ PS=0.65u PD=0.68u rfmode=0
M$554 \$696 RWL[7] RBL[2] GND sg13_lv_nmos L=0.13u W=0.3u AS=0.0525p AD=0.057p
+ PS=0.65u PD=0.68u rfmode=0
M$555 \$697 RWL[7] RBL[3] GND sg13_lv_nmos L=0.13u W=0.3u AS=0.0525p AD=0.057p
+ PS=0.65u PD=0.68u rfmode=0
M$556 \$698 RWL[7] RBL[4] GND sg13_lv_nmos L=0.13u W=0.3u AS=0.0525p AD=0.057p
+ PS=0.65u PD=0.68u rfmode=0
M$557 \$700 RWL[7] RBL[5] GND sg13_lv_nmos L=0.13u W=0.3u AS=0.0525p AD=0.057p
+ PS=0.65u PD=0.68u rfmode=0
M$558 \$702 RWL[7] RBL[6] GND sg13_lv_nmos L=0.13u W=0.3u AS=0.0525p AD=0.057p
+ PS=0.65u PD=0.68u rfmode=0
M$559 \$704 RWL[7] RBL[7] GND sg13_lv_nmos L=0.13u W=0.3u AS=0.0525p AD=0.057p
+ PS=0.65u PD=0.68u rfmode=0
M$560 \$705 RWL[7] RBL[8] GND sg13_lv_nmos L=0.13u W=0.3u AS=0.0525p AD=0.057p
+ PS=0.65u PD=0.68u rfmode=0
M$561 \$707 RWL[7] RBL[9] GND sg13_lv_nmos L=0.13u W=0.3u AS=0.0525p AD=0.057p
+ PS=0.65u PD=0.68u rfmode=0
M$562 \$709 RWL[7] RBL[10] GND sg13_lv_nmos L=0.13u W=0.3u AS=0.0525p AD=0.057p
+ PS=0.65u PD=0.68u rfmode=0
M$563 \$710 RWL[7] RBL[11] GND sg13_lv_nmos L=0.13u W=0.3u AS=0.0525p AD=0.057p
+ PS=0.65u PD=0.68u rfmode=0
M$564 \$712 RWL[7] RBL[12] GND sg13_lv_nmos L=0.13u W=0.3u AS=0.0525p AD=0.057p
+ PS=0.65u PD=0.68u rfmode=0
M$565 \$713 RWL[7] RBL[13] GND sg13_lv_nmos L=0.13u W=0.3u AS=0.0525p AD=0.057p
+ PS=0.65u PD=0.68u rfmode=0
M$566 \$715 RWL[7] RBL[14] GND sg13_lv_nmos L=0.13u W=0.3u AS=0.0525p AD=0.057p
+ PS=0.65u PD=0.68u rfmode=0
M$567 \$717 RWL[7] RBL[15] GND sg13_lv_nmos L=0.13u W=0.3u AS=0.0525p AD=0.057p
+ PS=0.65u PD=0.68u rfmode=0
M$568 \$718 RWL[7] RBL[16] GND sg13_lv_nmos L=0.13u W=0.3u AS=0.0525p AD=0.057p
+ PS=0.65u PD=0.68u rfmode=0
M$569 \$720 RWL[7] RBL[17] GND sg13_lv_nmos L=0.13u W=0.3u AS=0.0525p AD=0.057p
+ PS=0.65u PD=0.68u rfmode=0
M$570 \$722 RWL[7] RBL[18] GND sg13_lv_nmos L=0.13u W=0.3u AS=0.0525p AD=0.057p
+ PS=0.65u PD=0.68u rfmode=0
M$571 RBL[0] RWL[8] \$772 GND sg13_lv_nmos L=0.13u W=0.3u AS=0.057p AD=0.0525p
+ PS=0.68u PD=0.65u rfmode=0
M$572 RBL[1] RWL[8] \$773 GND sg13_lv_nmos L=0.13u W=0.3u AS=0.057p AD=0.0525p
+ PS=0.68u PD=0.65u rfmode=0
M$573 RBL[2] RWL[8] \$774 GND sg13_lv_nmos L=0.13u W=0.3u AS=0.057p AD=0.0525p
+ PS=0.68u PD=0.65u rfmode=0
M$574 RBL[3] RWL[8] \$776 GND sg13_lv_nmos L=0.13u W=0.3u AS=0.057p AD=0.0525p
+ PS=0.68u PD=0.65u rfmode=0
M$575 RBL[4] RWL[8] \$778 GND sg13_lv_nmos L=0.13u W=0.3u AS=0.057p AD=0.0525p
+ PS=0.68u PD=0.65u rfmode=0
M$576 RBL[5] RWL[8] \$779 GND sg13_lv_nmos L=0.13u W=0.3u AS=0.057p AD=0.0525p
+ PS=0.68u PD=0.65u rfmode=0
M$577 RBL[6] RWL[8] \$781 GND sg13_lv_nmos L=0.13u W=0.3u AS=0.057p AD=0.0525p
+ PS=0.68u PD=0.65u rfmode=0
M$578 RBL[7] RWL[8] \$782 GND sg13_lv_nmos L=0.13u W=0.3u AS=0.057p AD=0.0525p
+ PS=0.68u PD=0.65u rfmode=0
M$579 RBL[8] RWL[8] \$784 GND sg13_lv_nmos L=0.13u W=0.3u AS=0.057p AD=0.0525p
+ PS=0.68u PD=0.65u rfmode=0
M$580 RBL[9] RWL[8] \$786 GND sg13_lv_nmos L=0.13u W=0.3u AS=0.057p AD=0.0525p
+ PS=0.68u PD=0.65u rfmode=0
M$581 RBL[10] RWL[8] \$787 GND sg13_lv_nmos L=0.13u W=0.3u AS=0.057p AD=0.0525p
+ PS=0.68u PD=0.65u rfmode=0
M$582 RBL[11] RWL[8] \$789 GND sg13_lv_nmos L=0.13u W=0.3u AS=0.057p AD=0.0525p
+ PS=0.68u PD=0.65u rfmode=0
M$583 RBL[12] RWL[8] \$791 GND sg13_lv_nmos L=0.13u W=0.3u AS=0.057p AD=0.0525p
+ PS=0.68u PD=0.65u rfmode=0
M$584 RBL[13] RWL[8] \$792 GND sg13_lv_nmos L=0.13u W=0.3u AS=0.057p AD=0.0525p
+ PS=0.68u PD=0.65u rfmode=0
M$585 RBL[14] RWL[8] \$794 GND sg13_lv_nmos L=0.13u W=0.3u AS=0.057p AD=0.0525p
+ PS=0.68u PD=0.65u rfmode=0
M$586 RBL[15] RWL[8] \$795 GND sg13_lv_nmos L=0.13u W=0.3u AS=0.057p AD=0.0525p
+ PS=0.68u PD=0.65u rfmode=0
M$587 RBL[16] RWL[8] \$797 GND sg13_lv_nmos L=0.13u W=0.3u AS=0.057p AD=0.0525p
+ PS=0.68u PD=0.65u rfmode=0
M$588 RBL[17] RWL[8] \$799 GND sg13_lv_nmos L=0.13u W=0.3u AS=0.057p AD=0.0525p
+ PS=0.68u PD=0.65u rfmode=0
M$589 RBL[18] RWL[8] \$800 GND sg13_lv_nmos L=0.13u W=0.3u AS=0.057p AD=0.0525p
+ PS=0.68u PD=0.65u rfmode=0
M$590 \$772 \$732 GND GND sg13_lv_nmos L=0.13u W=0.3u AS=0.0525p
+ AD=0.331736842105p PS=0.65u PD=2.24315789474u rfmode=0
M$591 \$773 \$733 GND GND sg13_lv_nmos L=0.13u W=0.3u AS=0.0525p
+ AD=0.331736842105p PS=0.65u PD=2.24315789474u rfmode=0
M$592 \$774 \$734 GND GND sg13_lv_nmos L=0.13u W=0.3u AS=0.0525p
+ AD=0.331736842105p PS=0.65u PD=2.24315789474u rfmode=0
M$593 \$776 \$735 GND GND sg13_lv_nmos L=0.13u W=0.3u AS=0.0525p
+ AD=0.331736842105p PS=0.65u PD=2.24315789474u rfmode=0
M$594 \$778 \$736 GND GND sg13_lv_nmos L=0.13u W=0.3u AS=0.0525p
+ AD=0.331736842105p PS=0.65u PD=2.24315789474u rfmode=0
M$595 \$779 \$737 GND GND sg13_lv_nmos L=0.13u W=0.3u AS=0.0525p
+ AD=0.331736842105p PS=0.65u PD=2.24315789474u rfmode=0
M$596 \$781 \$738 GND GND sg13_lv_nmos L=0.13u W=0.3u AS=0.0525p
+ AD=0.331736842105p PS=0.65u PD=2.24315789474u rfmode=0
M$597 \$782 \$739 GND GND sg13_lv_nmos L=0.13u W=0.3u AS=0.0525p
+ AD=0.331736842105p PS=0.65u PD=2.24315789474u rfmode=0
M$598 \$784 \$740 GND GND sg13_lv_nmos L=0.13u W=0.3u AS=0.0525p
+ AD=0.331736842105p PS=0.65u PD=2.24315789474u rfmode=0
M$599 \$786 \$741 GND GND sg13_lv_nmos L=0.13u W=0.3u AS=0.0525p
+ AD=0.331736842105p PS=0.65u PD=2.24315789474u rfmode=0
M$600 \$787 \$742 GND GND sg13_lv_nmos L=0.13u W=0.3u AS=0.0525p
+ AD=0.331736842105p PS=0.65u PD=2.24315789474u rfmode=0
M$601 \$789 \$743 GND GND sg13_lv_nmos L=0.13u W=0.3u AS=0.0525p
+ AD=0.331736842105p PS=0.65u PD=2.24315789474u rfmode=0
M$602 \$791 \$744 GND GND sg13_lv_nmos L=0.13u W=0.3u AS=0.0525p
+ AD=0.331736842105p PS=0.65u PD=2.24315789474u rfmode=0
M$603 \$792 \$745 GND GND sg13_lv_nmos L=0.13u W=0.3u AS=0.0525p
+ AD=0.331736842105p PS=0.65u PD=2.24315789474u rfmode=0
M$604 \$794 \$746 GND GND sg13_lv_nmos L=0.13u W=0.3u AS=0.0525p
+ AD=0.331736842105p PS=0.65u PD=2.24315789474u rfmode=0
M$605 \$795 \$747 GND GND sg13_lv_nmos L=0.13u W=0.3u AS=0.0525p
+ AD=0.331736842105p PS=0.65u PD=2.24315789474u rfmode=0
M$606 \$797 \$748 GND GND sg13_lv_nmos L=0.13u W=0.3u AS=0.0525p
+ AD=0.331736842105p PS=0.65u PD=2.24315789474u rfmode=0
M$607 \$799 \$749 GND GND sg13_lv_nmos L=0.13u W=0.3u AS=0.0525p
+ AD=0.331736842105p PS=0.65u PD=2.24315789474u rfmode=0
M$608 \$800 \$750 GND GND sg13_lv_nmos L=0.13u W=0.3u AS=0.0525p
+ AD=0.331736842105p PS=0.65u PD=2.24315789474u rfmode=0
M$609 GND \$666 \$724 GND sg13_lv_nmos L=0.13u W=0.3u AS=0.331736842105p
+ AD=0.0525p PS=2.24315789474u PD=0.65u rfmode=0
M$610 GND \$667 \$725 GND sg13_lv_nmos L=0.13u W=0.3u AS=0.331736842105p
+ AD=0.0525p PS=2.24315789474u PD=0.65u rfmode=0
M$611 GND \$668 \$727 GND sg13_lv_nmos L=0.13u W=0.3u AS=0.331736842105p
+ AD=0.0525p PS=2.24315789474u PD=0.65u rfmode=0
M$612 GND \$669 \$728 GND sg13_lv_nmos L=0.13u W=0.3u AS=0.331736842105p
+ AD=0.0525p PS=2.24315789474u PD=0.65u rfmode=0
M$613 GND \$670 \$726 GND sg13_lv_nmos L=0.13u W=0.3u AS=0.331736842105p
+ AD=0.0525p PS=2.24315789474u PD=0.65u rfmode=0
M$614 GND \$671 \$723 GND sg13_lv_nmos L=0.13u W=0.3u AS=0.331736842105p
+ AD=0.0525p PS=2.24315789474u PD=0.65u rfmode=0
M$615 GND \$672 \$721 GND sg13_lv_nmos L=0.13u W=0.3u AS=0.331736842105p
+ AD=0.0525p PS=2.24315789474u PD=0.65u rfmode=0
M$616 GND \$673 \$719 GND sg13_lv_nmos L=0.13u W=0.3u AS=0.331736842105p
+ AD=0.0525p PS=2.24315789474u PD=0.65u rfmode=0
M$617 GND \$674 \$716 GND sg13_lv_nmos L=0.13u W=0.3u AS=0.331736842105p
+ AD=0.0525p PS=2.24315789474u PD=0.65u rfmode=0
M$618 GND \$675 \$714 GND sg13_lv_nmos L=0.13u W=0.3u AS=0.331736842105p
+ AD=0.0525p PS=2.24315789474u PD=0.65u rfmode=0
M$619 GND \$676 \$711 GND sg13_lv_nmos L=0.13u W=0.3u AS=0.331736842105p
+ AD=0.0525p PS=2.24315789474u PD=0.65u rfmode=0
M$620 GND \$677 \$708 GND sg13_lv_nmos L=0.13u W=0.3u AS=0.331736842105p
+ AD=0.0525p PS=2.24315789474u PD=0.65u rfmode=0
M$621 GND \$678 \$706 GND sg13_lv_nmos L=0.13u W=0.3u AS=0.331736842105p
+ AD=0.0525p PS=2.24315789474u PD=0.65u rfmode=0
M$622 GND \$679 \$703 GND sg13_lv_nmos L=0.13u W=0.3u AS=0.331736842105p
+ AD=0.0525p PS=2.24315789474u PD=0.65u rfmode=0
M$623 GND \$680 \$701 GND sg13_lv_nmos L=0.13u W=0.3u AS=0.331736842105p
+ AD=0.0525p PS=2.24315789474u PD=0.65u rfmode=0
M$624 GND \$681 \$699 GND sg13_lv_nmos L=0.13u W=0.3u AS=0.331736842105p
+ AD=0.0525p PS=2.24315789474u PD=0.65u rfmode=0
M$625 GND \$682 \$695 GND sg13_lv_nmos L=0.13u W=0.3u AS=0.331736842105p
+ AD=0.0525p PS=2.24315789474u PD=0.65u rfmode=0
M$626 GND \$683 \$693 GND sg13_lv_nmos L=0.13u W=0.3u AS=0.331736842105p
+ AD=0.0525p PS=2.24315789474u PD=0.65u rfmode=0
M$627 GND \$684 \$691 GND sg13_lv_nmos L=0.13u W=0.3u AS=0.331736842105p
+ AD=0.0525p PS=2.24315789474u PD=0.65u rfmode=0
M$628 \$724 RWL[7] RBL[19] GND sg13_lv_nmos L=0.13u W=0.3u AS=0.0525p AD=0.057p
+ PS=0.65u PD=0.68u rfmode=0
M$629 \$725 RWL[7] RBL[20] GND sg13_lv_nmos L=0.13u W=0.3u AS=0.0525p AD=0.057p
+ PS=0.65u PD=0.68u rfmode=0
M$630 \$727 RWL[7] RBL[21] GND sg13_lv_nmos L=0.13u W=0.3u AS=0.0525p AD=0.057p
+ PS=0.65u PD=0.68u rfmode=0
M$631 \$728 RWL[7] RBL[22] GND sg13_lv_nmos L=0.13u W=0.3u AS=0.0525p AD=0.057p
+ PS=0.65u PD=0.68u rfmode=0
M$632 \$726 RWL[7] RBL[23] GND sg13_lv_nmos L=0.13u W=0.3u AS=0.0525p AD=0.057p
+ PS=0.65u PD=0.68u rfmode=0
M$633 \$723 RWL[7] RBL[24] GND sg13_lv_nmos L=0.13u W=0.3u AS=0.0525p AD=0.057p
+ PS=0.65u PD=0.68u rfmode=0
M$634 \$721 RWL[7] RBL[25] GND sg13_lv_nmos L=0.13u W=0.3u AS=0.0525p AD=0.057p
+ PS=0.65u PD=0.68u rfmode=0
M$635 \$719 RWL[7] RBL[26] GND sg13_lv_nmos L=0.13u W=0.3u AS=0.0525p AD=0.057p
+ PS=0.65u PD=0.68u rfmode=0
M$636 \$716 RWL[7] RBL[27] GND sg13_lv_nmos L=0.13u W=0.3u AS=0.0525p AD=0.057p
+ PS=0.65u PD=0.68u rfmode=0
M$637 \$714 RWL[7] RBL[28] GND sg13_lv_nmos L=0.13u W=0.3u AS=0.0525p AD=0.057p
+ PS=0.65u PD=0.68u rfmode=0
M$638 \$711 RWL[7] RBL[29] GND sg13_lv_nmos L=0.13u W=0.3u AS=0.0525p AD=0.057p
+ PS=0.65u PD=0.68u rfmode=0
M$639 \$708 RWL[7] RBL[30] GND sg13_lv_nmos L=0.13u W=0.3u AS=0.0525p AD=0.057p
+ PS=0.65u PD=0.68u rfmode=0
M$640 \$706 RWL[7] RBL[31] GND sg13_lv_nmos L=0.13u W=0.3u AS=0.0525p AD=0.057p
+ PS=0.65u PD=0.68u rfmode=0
M$641 \$703 RWL[7] RBL[32] GND sg13_lv_nmos L=0.13u W=0.3u AS=0.0525p AD=0.057p
+ PS=0.65u PD=0.68u rfmode=0
M$642 \$701 RWL[7] RBL[33] GND sg13_lv_nmos L=0.13u W=0.3u AS=0.0525p AD=0.057p
+ PS=0.65u PD=0.68u rfmode=0
M$643 \$699 RWL[7] RBL[34] GND sg13_lv_nmos L=0.13u W=0.3u AS=0.0525p AD=0.057p
+ PS=0.65u PD=0.68u rfmode=0
M$644 \$695 RWL[7] RBL[35] GND sg13_lv_nmos L=0.13u W=0.3u AS=0.0525p AD=0.057p
+ PS=0.65u PD=0.68u rfmode=0
M$645 \$693 RWL[7] RBL[36] GND sg13_lv_nmos L=0.13u W=0.3u AS=0.0525p AD=0.057p
+ PS=0.65u PD=0.68u rfmode=0
M$646 \$691 RWL[7] RBL[37] GND sg13_lv_nmos L=0.13u W=0.3u AS=0.0525p AD=0.057p
+ PS=0.65u PD=0.68u rfmode=0
M$647 RBL[19] RWL[8] \$803 GND sg13_lv_nmos L=0.13u W=0.3u AS=0.057p AD=0.0525p
+ PS=0.68u PD=0.65u rfmode=0
M$648 RBL[20] RWL[8] \$804 GND sg13_lv_nmos L=0.13u W=0.3u AS=0.057p AD=0.0525p
+ PS=0.68u PD=0.65u rfmode=0
M$649 RBL[21] RWL[8] \$806 GND sg13_lv_nmos L=0.13u W=0.3u AS=0.057p AD=0.0525p
+ PS=0.68u PD=0.65u rfmode=0
M$650 RBL[22] RWL[8] \$808 GND sg13_lv_nmos L=0.13u W=0.3u AS=0.057p AD=0.0525p
+ PS=0.68u PD=0.65u rfmode=0
M$651 RBL[23] RWL[8] \$809 GND sg13_lv_nmos L=0.13u W=0.3u AS=0.057p AD=0.0525p
+ PS=0.68u PD=0.65u rfmode=0
M$652 RBL[24] RWL[8] \$807 GND sg13_lv_nmos L=0.13u W=0.3u AS=0.057p AD=0.0525p
+ PS=0.68u PD=0.65u rfmode=0
M$653 RBL[25] RWL[8] \$805 GND sg13_lv_nmos L=0.13u W=0.3u AS=0.057p AD=0.0525p
+ PS=0.68u PD=0.65u rfmode=0
M$654 RBL[26] RWL[8] \$802 GND sg13_lv_nmos L=0.13u W=0.3u AS=0.057p AD=0.0525p
+ PS=0.68u PD=0.65u rfmode=0
M$655 RBL[27] RWL[8] \$801 GND sg13_lv_nmos L=0.13u W=0.3u AS=0.057p AD=0.0525p
+ PS=0.68u PD=0.65u rfmode=0
M$656 RBL[28] RWL[8] \$798 GND sg13_lv_nmos L=0.13u W=0.3u AS=0.057p AD=0.0525p
+ PS=0.68u PD=0.65u rfmode=0
M$657 RBL[29] RWL[8] \$796 GND sg13_lv_nmos L=0.13u W=0.3u AS=0.057p AD=0.0525p
+ PS=0.68u PD=0.65u rfmode=0
M$658 RBL[30] RWL[8] \$793 GND sg13_lv_nmos L=0.13u W=0.3u AS=0.057p AD=0.0525p
+ PS=0.68u PD=0.65u rfmode=0
M$659 RBL[31] RWL[8] \$790 GND sg13_lv_nmos L=0.13u W=0.3u AS=0.057p AD=0.0525p
+ PS=0.68u PD=0.65u rfmode=0
M$660 RBL[32] RWL[8] \$788 GND sg13_lv_nmos L=0.13u W=0.3u AS=0.057p AD=0.0525p
+ PS=0.68u PD=0.65u rfmode=0
M$661 RBL[33] RWL[8] \$785 GND sg13_lv_nmos L=0.13u W=0.3u AS=0.057p AD=0.0525p
+ PS=0.68u PD=0.65u rfmode=0
M$662 RBL[34] RWL[8] \$783 GND sg13_lv_nmos L=0.13u W=0.3u AS=0.057p AD=0.0525p
+ PS=0.68u PD=0.65u rfmode=0
M$663 RBL[35] RWL[8] \$780 GND sg13_lv_nmos L=0.13u W=0.3u AS=0.057p AD=0.0525p
+ PS=0.68u PD=0.65u rfmode=0
M$664 RBL[36] RWL[8] \$777 GND sg13_lv_nmos L=0.13u W=0.3u AS=0.057p AD=0.0525p
+ PS=0.68u PD=0.65u rfmode=0
M$665 RBL[37] RWL[8] \$775 GND sg13_lv_nmos L=0.13u W=0.3u AS=0.057p AD=0.0525p
+ PS=0.68u PD=0.65u rfmode=0
M$666 \$803 \$751 GND GND sg13_lv_nmos L=0.13u W=0.3u AS=0.0525p
+ AD=0.331736842105p PS=0.65u PD=2.24315789474u rfmode=0
M$667 \$804 \$752 GND GND sg13_lv_nmos L=0.13u W=0.3u AS=0.0525p
+ AD=0.331736842105p PS=0.65u PD=2.24315789474u rfmode=0
M$668 \$806 \$753 GND GND sg13_lv_nmos L=0.13u W=0.3u AS=0.0525p
+ AD=0.331736842105p PS=0.65u PD=2.24315789474u rfmode=0
M$669 \$808 \$754 GND GND sg13_lv_nmos L=0.13u W=0.3u AS=0.0525p
+ AD=0.331736842105p PS=0.65u PD=2.24315789474u rfmode=0
M$670 \$809 \$755 GND GND sg13_lv_nmos L=0.13u W=0.3u AS=0.0525p
+ AD=0.331736842105p PS=0.65u PD=2.24315789474u rfmode=0
M$671 \$807 \$756 GND GND sg13_lv_nmos L=0.13u W=0.3u AS=0.0525p
+ AD=0.331736842105p PS=0.65u PD=2.24315789474u rfmode=0
M$672 \$805 \$757 GND GND sg13_lv_nmos L=0.13u W=0.3u AS=0.0525p
+ AD=0.331736842105p PS=0.65u PD=2.24315789474u rfmode=0
M$673 \$802 \$758 GND GND sg13_lv_nmos L=0.13u W=0.3u AS=0.0525p
+ AD=0.331736842105p PS=0.65u PD=2.24315789474u rfmode=0
M$674 \$801 \$759 GND GND sg13_lv_nmos L=0.13u W=0.3u AS=0.0525p
+ AD=0.331736842105p PS=0.65u PD=2.24315789474u rfmode=0
M$675 \$798 \$760 GND GND sg13_lv_nmos L=0.13u W=0.3u AS=0.0525p
+ AD=0.331736842105p PS=0.65u PD=2.24315789474u rfmode=0
M$676 \$796 \$761 GND GND sg13_lv_nmos L=0.13u W=0.3u AS=0.0525p
+ AD=0.331736842105p PS=0.65u PD=2.24315789474u rfmode=0
M$677 \$793 \$762 GND GND sg13_lv_nmos L=0.13u W=0.3u AS=0.0525p
+ AD=0.331736842105p PS=0.65u PD=2.24315789474u rfmode=0
M$678 \$790 \$763 GND GND sg13_lv_nmos L=0.13u W=0.3u AS=0.0525p
+ AD=0.331736842105p PS=0.65u PD=2.24315789474u rfmode=0
M$679 \$788 \$764 GND GND sg13_lv_nmos L=0.13u W=0.3u AS=0.0525p
+ AD=0.331736842105p PS=0.65u PD=2.24315789474u rfmode=0
M$680 \$785 \$765 GND GND sg13_lv_nmos L=0.13u W=0.3u AS=0.0525p
+ AD=0.331736842105p PS=0.65u PD=2.24315789474u rfmode=0
M$681 \$783 \$766 GND GND sg13_lv_nmos L=0.13u W=0.3u AS=0.0525p
+ AD=0.331736842105p PS=0.65u PD=2.24315789474u rfmode=0
M$682 \$780 \$767 GND GND sg13_lv_nmos L=0.13u W=0.3u AS=0.0525p
+ AD=0.331736842105p PS=0.65u PD=2.24315789474u rfmode=0
M$683 \$777 \$768 GND GND sg13_lv_nmos L=0.13u W=0.3u AS=0.0525p
+ AD=0.331736842105p PS=0.65u PD=2.24315789474u rfmode=0
M$684 \$775 \$769 GND GND sg13_lv_nmos L=0.13u W=0.3u AS=0.0525p
+ AD=0.331736842105p PS=0.65u PD=2.24315789474u rfmode=0
M$685 GND \$810 \$855 GND sg13_lv_nmos L=0.13u W=0.3u AS=0.331736842105p
+ AD=0.0525p PS=2.24315789474u PD=0.65u rfmode=0
M$686 GND \$811 \$857 GND sg13_lv_nmos L=0.13u W=0.3u AS=0.331736842105p
+ AD=0.0525p PS=2.24315789474u PD=0.65u rfmode=0
M$687 GND \$812 \$859 GND sg13_lv_nmos L=0.13u W=0.3u AS=0.331736842105p
+ AD=0.0525p PS=2.24315789474u PD=0.65u rfmode=0
M$688 GND \$813 \$860 GND sg13_lv_nmos L=0.13u W=0.3u AS=0.331736842105p
+ AD=0.0525p PS=2.24315789474u PD=0.65u rfmode=0
M$689 GND \$814 \$862 GND sg13_lv_nmos L=0.13u W=0.3u AS=0.331736842105p
+ AD=0.0525p PS=2.24315789474u PD=0.65u rfmode=0
M$690 GND \$815 \$863 GND sg13_lv_nmos L=0.13u W=0.3u AS=0.331736842105p
+ AD=0.0525p PS=2.24315789474u PD=0.65u rfmode=0
M$691 GND \$816 \$865 GND sg13_lv_nmos L=0.13u W=0.3u AS=0.331736842105p
+ AD=0.0525p PS=2.24315789474u PD=0.65u rfmode=0
M$692 GND \$817 \$867 GND sg13_lv_nmos L=0.13u W=0.3u AS=0.331736842105p
+ AD=0.0525p PS=2.24315789474u PD=0.65u rfmode=0
M$693 GND \$818 \$868 GND sg13_lv_nmos L=0.13u W=0.3u AS=0.331736842105p
+ AD=0.0525p PS=2.24315789474u PD=0.65u rfmode=0
M$694 GND \$819 \$870 GND sg13_lv_nmos L=0.13u W=0.3u AS=0.331736842105p
+ AD=0.0525p PS=2.24315789474u PD=0.65u rfmode=0
M$695 GND \$820 \$872 GND sg13_lv_nmos L=0.13u W=0.3u AS=0.331736842105p
+ AD=0.0525p PS=2.24315789474u PD=0.65u rfmode=0
M$696 GND \$821 \$873 GND sg13_lv_nmos L=0.13u W=0.3u AS=0.331736842105p
+ AD=0.0525p PS=2.24315789474u PD=0.65u rfmode=0
M$697 GND \$822 \$875 GND sg13_lv_nmos L=0.13u W=0.3u AS=0.331736842105p
+ AD=0.0525p PS=2.24315789474u PD=0.65u rfmode=0
M$698 GND \$823 \$876 GND sg13_lv_nmos L=0.13u W=0.3u AS=0.331736842105p
+ AD=0.0525p PS=2.24315789474u PD=0.65u rfmode=0
M$699 GND \$824 \$878 GND sg13_lv_nmos L=0.13u W=0.3u AS=0.331736842105p
+ AD=0.0525p PS=2.24315789474u PD=0.65u rfmode=0
M$700 GND \$825 \$879 GND sg13_lv_nmos L=0.13u W=0.3u AS=0.331736842105p
+ AD=0.0525p PS=2.24315789474u PD=0.65u rfmode=0
M$701 GND \$826 \$881 GND sg13_lv_nmos L=0.13u W=0.3u AS=0.331736842105p
+ AD=0.0525p PS=2.24315789474u PD=0.65u rfmode=0
M$702 GND \$827 \$883 GND sg13_lv_nmos L=0.13u W=0.3u AS=0.331736842105p
+ AD=0.0525p PS=2.24315789474u PD=0.65u rfmode=0
M$703 GND \$828 \$884 GND sg13_lv_nmos L=0.13u W=0.3u AS=0.331736842105p
+ AD=0.0525p PS=2.24315789474u PD=0.65u rfmode=0
M$704 \$855 RWL[9] RBL[0] GND sg13_lv_nmos L=0.13u W=0.3u AS=0.0525p AD=0.057p
+ PS=0.65u PD=0.68u rfmode=0
M$705 \$857 RWL[9] RBL[1] GND sg13_lv_nmos L=0.13u W=0.3u AS=0.0525p AD=0.057p
+ PS=0.65u PD=0.68u rfmode=0
M$706 \$859 RWL[9] RBL[2] GND sg13_lv_nmos L=0.13u W=0.3u AS=0.0525p AD=0.057p
+ PS=0.65u PD=0.68u rfmode=0
M$707 \$860 RWL[9] RBL[3] GND sg13_lv_nmos L=0.13u W=0.3u AS=0.0525p AD=0.057p
+ PS=0.65u PD=0.68u rfmode=0
M$708 \$862 RWL[9] RBL[4] GND sg13_lv_nmos L=0.13u W=0.3u AS=0.0525p AD=0.057p
+ PS=0.65u PD=0.68u rfmode=0
M$709 \$863 RWL[9] RBL[5] GND sg13_lv_nmos L=0.13u W=0.3u AS=0.0525p AD=0.057p
+ PS=0.65u PD=0.68u rfmode=0
M$710 \$865 RWL[9] RBL[6] GND sg13_lv_nmos L=0.13u W=0.3u AS=0.0525p AD=0.057p
+ PS=0.65u PD=0.68u rfmode=0
M$711 \$867 RWL[9] RBL[7] GND sg13_lv_nmos L=0.13u W=0.3u AS=0.0525p AD=0.057p
+ PS=0.65u PD=0.68u rfmode=0
M$712 \$868 RWL[9] RBL[8] GND sg13_lv_nmos L=0.13u W=0.3u AS=0.0525p AD=0.057p
+ PS=0.65u PD=0.68u rfmode=0
M$713 \$870 RWL[9] RBL[9] GND sg13_lv_nmos L=0.13u W=0.3u AS=0.0525p AD=0.057p
+ PS=0.65u PD=0.68u rfmode=0
M$714 \$872 RWL[9] RBL[10] GND sg13_lv_nmos L=0.13u W=0.3u AS=0.0525p AD=0.057p
+ PS=0.65u PD=0.68u rfmode=0
M$715 \$873 RWL[9] RBL[11] GND sg13_lv_nmos L=0.13u W=0.3u AS=0.0525p AD=0.057p
+ PS=0.65u PD=0.68u rfmode=0
M$716 \$875 RWL[9] RBL[12] GND sg13_lv_nmos L=0.13u W=0.3u AS=0.0525p AD=0.057p
+ PS=0.65u PD=0.68u rfmode=0
M$717 \$876 RWL[9] RBL[13] GND sg13_lv_nmos L=0.13u W=0.3u AS=0.0525p AD=0.057p
+ PS=0.65u PD=0.68u rfmode=0
M$718 \$878 RWL[9] RBL[14] GND sg13_lv_nmos L=0.13u W=0.3u AS=0.0525p AD=0.057p
+ PS=0.65u PD=0.68u rfmode=0
M$719 \$879 RWL[9] RBL[15] GND sg13_lv_nmos L=0.13u W=0.3u AS=0.0525p AD=0.057p
+ PS=0.65u PD=0.68u rfmode=0
M$720 \$881 RWL[9] RBL[16] GND sg13_lv_nmos L=0.13u W=0.3u AS=0.0525p AD=0.057p
+ PS=0.65u PD=0.68u rfmode=0
M$721 \$883 RWL[9] RBL[17] GND sg13_lv_nmos L=0.13u W=0.3u AS=0.0525p AD=0.057p
+ PS=0.65u PD=0.68u rfmode=0
M$722 \$884 RWL[9] RBL[18] GND sg13_lv_nmos L=0.13u W=0.3u AS=0.0525p AD=0.057p
+ PS=0.65u PD=0.68u rfmode=0
M$723 RBL[0] RWL[10] \$935 GND sg13_lv_nmos L=0.13u W=0.3u AS=0.057p AD=0.0525p
+ PS=0.68u PD=0.65u rfmode=0
M$724 RBL[1] RWL[10] \$936 GND sg13_lv_nmos L=0.13u W=0.3u AS=0.057p AD=0.0525p
+ PS=0.68u PD=0.65u rfmode=0
M$725 RBL[2] RWL[10] \$937 GND sg13_lv_nmos L=0.13u W=0.3u AS=0.057p AD=0.0525p
+ PS=0.68u PD=0.65u rfmode=0
M$726 RBL[3] RWL[10] \$939 GND sg13_lv_nmos L=0.13u W=0.3u AS=0.057p AD=0.0525p
+ PS=0.68u PD=0.65u rfmode=0
M$727 RBL[4] RWL[10] \$940 GND sg13_lv_nmos L=0.13u W=0.3u AS=0.057p AD=0.0525p
+ PS=0.68u PD=0.65u rfmode=0
M$728 RBL[5] RWL[10] \$942 GND sg13_lv_nmos L=0.13u W=0.3u AS=0.057p AD=0.0525p
+ PS=0.68u PD=0.65u rfmode=0
M$729 RBL[6] RWL[10] \$944 GND sg13_lv_nmos L=0.13u W=0.3u AS=0.057p AD=0.0525p
+ PS=0.68u PD=0.65u rfmode=0
M$730 RBL[7] RWL[10] \$945 GND sg13_lv_nmos L=0.13u W=0.3u AS=0.057p AD=0.0525p
+ PS=0.68u PD=0.65u rfmode=0
M$731 RBL[8] RWL[10] \$947 GND sg13_lv_nmos L=0.13u W=0.3u AS=0.057p AD=0.0525p
+ PS=0.68u PD=0.65u rfmode=0
M$732 RBL[9] RWL[10] \$949 GND sg13_lv_nmos L=0.13u W=0.3u AS=0.057p AD=0.0525p
+ PS=0.68u PD=0.65u rfmode=0
M$733 RBL[10] RWL[10] \$950 GND sg13_lv_nmos L=0.13u W=0.3u AS=0.057p
+ AD=0.0525p PS=0.68u PD=0.65u rfmode=0
M$734 RBL[11] RWL[10] \$952 GND sg13_lv_nmos L=0.13u W=0.3u AS=0.057p
+ AD=0.0525p PS=0.68u PD=0.65u rfmode=0
M$735 RBL[12] RWL[10] \$954 GND sg13_lv_nmos L=0.13u W=0.3u AS=0.057p
+ AD=0.0525p PS=0.68u PD=0.65u rfmode=0
M$736 RBL[13] RWL[10] \$955 GND sg13_lv_nmos L=0.13u W=0.3u AS=0.057p
+ AD=0.0525p PS=0.68u PD=0.65u rfmode=0
M$737 RBL[14] RWL[10] \$957 GND sg13_lv_nmos L=0.13u W=0.3u AS=0.057p
+ AD=0.0525p PS=0.68u PD=0.65u rfmode=0
M$738 RBL[15] RWL[10] \$959 GND sg13_lv_nmos L=0.13u W=0.3u AS=0.057p
+ AD=0.0525p PS=0.68u PD=0.65u rfmode=0
M$739 RBL[16] RWL[10] \$960 GND sg13_lv_nmos L=0.13u W=0.3u AS=0.057p
+ AD=0.0525p PS=0.68u PD=0.65u rfmode=0
M$740 RBL[17] RWL[10] \$962 GND sg13_lv_nmos L=0.13u W=0.3u AS=0.057p
+ AD=0.0525p PS=0.68u PD=0.65u rfmode=0
M$741 RBL[18] RWL[10] \$963 GND sg13_lv_nmos L=0.13u W=0.3u AS=0.057p
+ AD=0.0525p PS=0.68u PD=0.65u rfmode=0
M$742 \$935 \$895 GND GND sg13_lv_nmos L=0.13u W=0.3u AS=0.0525p
+ AD=0.331736842105p PS=0.65u PD=2.24315789474u rfmode=0
M$743 \$936 \$896 GND GND sg13_lv_nmos L=0.13u W=0.3u AS=0.0525p
+ AD=0.331736842105p PS=0.65u PD=2.24315789474u rfmode=0
M$744 \$937 \$897 GND GND sg13_lv_nmos L=0.13u W=0.3u AS=0.0525p
+ AD=0.331736842105p PS=0.65u PD=2.24315789474u rfmode=0
M$745 \$939 \$898 GND GND sg13_lv_nmos L=0.13u W=0.3u AS=0.0525p
+ AD=0.331736842105p PS=0.65u PD=2.24315789474u rfmode=0
M$746 \$940 \$899 GND GND sg13_lv_nmos L=0.13u W=0.3u AS=0.0525p
+ AD=0.331736842105p PS=0.65u PD=2.24315789474u rfmode=0
M$747 \$942 \$900 GND GND sg13_lv_nmos L=0.13u W=0.3u AS=0.0525p
+ AD=0.331736842105p PS=0.65u PD=2.24315789474u rfmode=0
M$748 \$944 \$901 GND GND sg13_lv_nmos L=0.13u W=0.3u AS=0.0525p
+ AD=0.331736842105p PS=0.65u PD=2.24315789474u rfmode=0
M$749 \$945 \$902 GND GND sg13_lv_nmos L=0.13u W=0.3u AS=0.0525p
+ AD=0.331736842105p PS=0.65u PD=2.24315789474u rfmode=0
M$750 \$947 \$903 GND GND sg13_lv_nmos L=0.13u W=0.3u AS=0.0525p
+ AD=0.331736842105p PS=0.65u PD=2.24315789474u rfmode=0
M$751 \$949 \$904 GND GND sg13_lv_nmos L=0.13u W=0.3u AS=0.0525p
+ AD=0.331736842105p PS=0.65u PD=2.24315789474u rfmode=0
M$752 \$950 \$905 GND GND sg13_lv_nmos L=0.13u W=0.3u AS=0.0525p
+ AD=0.331736842105p PS=0.65u PD=2.24315789474u rfmode=0
M$753 \$952 \$906 GND GND sg13_lv_nmos L=0.13u W=0.3u AS=0.0525p
+ AD=0.331736842105p PS=0.65u PD=2.24315789474u rfmode=0
M$754 \$954 \$907 GND GND sg13_lv_nmos L=0.13u W=0.3u AS=0.0525p
+ AD=0.331736842105p PS=0.65u PD=2.24315789474u rfmode=0
M$755 \$955 \$908 GND GND sg13_lv_nmos L=0.13u W=0.3u AS=0.0525p
+ AD=0.331736842105p PS=0.65u PD=2.24315789474u rfmode=0
M$756 \$957 \$909 GND GND sg13_lv_nmos L=0.13u W=0.3u AS=0.0525p
+ AD=0.331736842105p PS=0.65u PD=2.24315789474u rfmode=0
M$757 \$959 \$910 GND GND sg13_lv_nmos L=0.13u W=0.3u AS=0.0525p
+ AD=0.331736842105p PS=0.65u PD=2.24315789474u rfmode=0
M$758 \$960 \$911 GND GND sg13_lv_nmos L=0.13u W=0.3u AS=0.0525p
+ AD=0.331736842105p PS=0.65u PD=2.24315789474u rfmode=0
M$759 \$962 \$912 GND GND sg13_lv_nmos L=0.13u W=0.3u AS=0.0525p
+ AD=0.331736842105p PS=0.65u PD=2.24315789474u rfmode=0
M$760 \$963 \$913 GND GND sg13_lv_nmos L=0.13u W=0.3u AS=0.0525p
+ AD=0.331736842105p PS=0.65u PD=2.24315789474u rfmode=0
M$761 GND \$829 \$887 GND sg13_lv_nmos L=0.13u W=0.3u AS=0.331736842105p
+ AD=0.0525p PS=2.24315789474u PD=0.65u rfmode=0
M$762 GND \$830 \$888 GND sg13_lv_nmos L=0.13u W=0.3u AS=0.331736842105p
+ AD=0.0525p PS=2.24315789474u PD=0.65u rfmode=0
M$763 GND \$831 \$890 GND sg13_lv_nmos L=0.13u W=0.3u AS=0.331736842105p
+ AD=0.0525p PS=2.24315789474u PD=0.65u rfmode=0
M$764 GND \$832 \$891 GND sg13_lv_nmos L=0.13u W=0.3u AS=0.331736842105p
+ AD=0.0525p PS=2.24315789474u PD=0.65u rfmode=0
M$765 GND \$833 \$889 GND sg13_lv_nmos L=0.13u W=0.3u AS=0.331736842105p
+ AD=0.0525p PS=2.24315789474u PD=0.65u rfmode=0
M$766 GND \$834 \$886 GND sg13_lv_nmos L=0.13u W=0.3u AS=0.331736842105p
+ AD=0.0525p PS=2.24315789474u PD=0.65u rfmode=0
M$767 GND \$835 \$885 GND sg13_lv_nmos L=0.13u W=0.3u AS=0.331736842105p
+ AD=0.0525p PS=2.24315789474u PD=0.65u rfmode=0
M$768 GND \$836 \$882 GND sg13_lv_nmos L=0.13u W=0.3u AS=0.331736842105p
+ AD=0.0525p PS=2.24315789474u PD=0.65u rfmode=0
M$769 GND \$837 \$880 GND sg13_lv_nmos L=0.13u W=0.3u AS=0.331736842105p
+ AD=0.0525p PS=2.24315789474u PD=0.65u rfmode=0
M$770 GND \$838 \$877 GND sg13_lv_nmos L=0.13u W=0.3u AS=0.331736842105p
+ AD=0.0525p PS=2.24315789474u PD=0.65u rfmode=0
M$771 GND \$839 \$874 GND sg13_lv_nmos L=0.13u W=0.3u AS=0.331736842105p
+ AD=0.0525p PS=2.24315789474u PD=0.65u rfmode=0
M$772 GND \$840 \$871 GND sg13_lv_nmos L=0.13u W=0.3u AS=0.331736842105p
+ AD=0.0525p PS=2.24315789474u PD=0.65u rfmode=0
M$773 GND \$841 \$869 GND sg13_lv_nmos L=0.13u W=0.3u AS=0.331736842105p
+ AD=0.0525p PS=2.24315789474u PD=0.65u rfmode=0
M$774 GND \$842 \$866 GND sg13_lv_nmos L=0.13u W=0.3u AS=0.331736842105p
+ AD=0.0525p PS=2.24315789474u PD=0.65u rfmode=0
M$775 GND \$843 \$864 GND sg13_lv_nmos L=0.13u W=0.3u AS=0.331736842105p
+ AD=0.0525p PS=2.24315789474u PD=0.65u rfmode=0
M$776 GND \$844 \$861 GND sg13_lv_nmos L=0.13u W=0.3u AS=0.331736842105p
+ AD=0.0525p PS=2.24315789474u PD=0.65u rfmode=0
M$777 GND \$845 \$858 GND sg13_lv_nmos L=0.13u W=0.3u AS=0.331736842105p
+ AD=0.0525p PS=2.24315789474u PD=0.65u rfmode=0
M$778 GND \$846 \$856 GND sg13_lv_nmos L=0.13u W=0.3u AS=0.331736842105p
+ AD=0.0525p PS=2.24315789474u PD=0.65u rfmode=0
M$779 GND \$847 \$854 GND sg13_lv_nmos L=0.13u W=0.3u AS=0.331736842105p
+ AD=0.0525p PS=2.24315789474u PD=0.65u rfmode=0
M$780 \$887 RWL[9] RBL[19] GND sg13_lv_nmos L=0.13u W=0.3u AS=0.0525p AD=0.057p
+ PS=0.65u PD=0.68u rfmode=0
M$781 \$888 RWL[9] RBL[20] GND sg13_lv_nmos L=0.13u W=0.3u AS=0.0525p AD=0.057p
+ PS=0.65u PD=0.68u rfmode=0
M$782 \$890 RWL[9] RBL[21] GND sg13_lv_nmos L=0.13u W=0.3u AS=0.0525p AD=0.057p
+ PS=0.65u PD=0.68u rfmode=0
M$783 \$891 RWL[9] RBL[22] GND sg13_lv_nmos L=0.13u W=0.3u AS=0.0525p AD=0.057p
+ PS=0.65u PD=0.68u rfmode=0
M$784 \$889 RWL[9] RBL[23] GND sg13_lv_nmos L=0.13u W=0.3u AS=0.0525p AD=0.057p
+ PS=0.65u PD=0.68u rfmode=0
M$785 \$886 RWL[9] RBL[24] GND sg13_lv_nmos L=0.13u W=0.3u AS=0.0525p AD=0.057p
+ PS=0.65u PD=0.68u rfmode=0
M$786 \$885 RWL[9] RBL[25] GND sg13_lv_nmos L=0.13u W=0.3u AS=0.0525p AD=0.057p
+ PS=0.65u PD=0.68u rfmode=0
M$787 \$882 RWL[9] RBL[26] GND sg13_lv_nmos L=0.13u W=0.3u AS=0.0525p AD=0.057p
+ PS=0.65u PD=0.68u rfmode=0
M$788 \$880 RWL[9] RBL[27] GND sg13_lv_nmos L=0.13u W=0.3u AS=0.0525p AD=0.057p
+ PS=0.65u PD=0.68u rfmode=0
M$789 \$877 RWL[9] RBL[28] GND sg13_lv_nmos L=0.13u W=0.3u AS=0.0525p AD=0.057p
+ PS=0.65u PD=0.68u rfmode=0
M$790 \$874 RWL[9] RBL[29] GND sg13_lv_nmos L=0.13u W=0.3u AS=0.0525p AD=0.057p
+ PS=0.65u PD=0.68u rfmode=0
M$791 \$871 RWL[9] RBL[30] GND sg13_lv_nmos L=0.13u W=0.3u AS=0.0525p AD=0.057p
+ PS=0.65u PD=0.68u rfmode=0
M$792 \$869 RWL[9] RBL[31] GND sg13_lv_nmos L=0.13u W=0.3u AS=0.0525p AD=0.057p
+ PS=0.65u PD=0.68u rfmode=0
M$793 \$866 RWL[9] RBL[32] GND sg13_lv_nmos L=0.13u W=0.3u AS=0.0525p AD=0.057p
+ PS=0.65u PD=0.68u rfmode=0
M$794 \$864 RWL[9] RBL[33] GND sg13_lv_nmos L=0.13u W=0.3u AS=0.0525p AD=0.057p
+ PS=0.65u PD=0.68u rfmode=0
M$795 \$861 RWL[9] RBL[34] GND sg13_lv_nmos L=0.13u W=0.3u AS=0.0525p AD=0.057p
+ PS=0.65u PD=0.68u rfmode=0
M$796 \$858 RWL[9] RBL[35] GND sg13_lv_nmos L=0.13u W=0.3u AS=0.0525p AD=0.057p
+ PS=0.65u PD=0.68u rfmode=0
M$797 \$856 RWL[9] RBL[36] GND sg13_lv_nmos L=0.13u W=0.3u AS=0.0525p AD=0.057p
+ PS=0.65u PD=0.68u rfmode=0
M$798 \$854 RWL[9] RBL[37] GND sg13_lv_nmos L=0.13u W=0.3u AS=0.0525p AD=0.057p
+ PS=0.65u PD=0.68u rfmode=0
M$799 RBL[19] RWL[10] \$966 GND sg13_lv_nmos L=0.13u W=0.3u AS=0.057p
+ AD=0.0525p PS=0.68u PD=0.65u rfmode=0
M$800 RBL[20] RWL[10] \$967 GND sg13_lv_nmos L=0.13u W=0.3u AS=0.057p
+ AD=0.0525p PS=0.68u PD=0.65u rfmode=0
M$801 RBL[21] RWL[10] \$969 GND sg13_lv_nmos L=0.13u W=0.3u AS=0.057p
+ AD=0.0525p PS=0.68u PD=0.65u rfmode=0
M$802 RBL[22] RWL[10] \$971 GND sg13_lv_nmos L=0.13u W=0.3u AS=0.057p
+ AD=0.0525p PS=0.68u PD=0.65u rfmode=0
M$803 RBL[23] RWL[10] \$972 GND sg13_lv_nmos L=0.13u W=0.3u AS=0.057p
+ AD=0.0525p PS=0.68u PD=0.65u rfmode=0
M$804 RBL[24] RWL[10] \$970 GND sg13_lv_nmos L=0.13u W=0.3u AS=0.057p
+ AD=0.0525p PS=0.68u PD=0.65u rfmode=0
M$805 RBL[25] RWL[10] \$968 GND sg13_lv_nmos L=0.13u W=0.3u AS=0.057p
+ AD=0.0525p PS=0.68u PD=0.65u rfmode=0
M$806 RBL[26] RWL[10] \$965 GND sg13_lv_nmos L=0.13u W=0.3u AS=0.057p
+ AD=0.0525p PS=0.68u PD=0.65u rfmode=0
M$807 RBL[27] RWL[10] \$964 GND sg13_lv_nmos L=0.13u W=0.3u AS=0.057p
+ AD=0.0525p PS=0.68u PD=0.65u rfmode=0
M$808 RBL[28] RWL[10] \$961 GND sg13_lv_nmos L=0.13u W=0.3u AS=0.057p
+ AD=0.0525p PS=0.68u PD=0.65u rfmode=0
M$809 RBL[29] RWL[10] \$958 GND sg13_lv_nmos L=0.13u W=0.3u AS=0.057p
+ AD=0.0525p PS=0.68u PD=0.65u rfmode=0
M$810 RBL[30] RWL[10] \$956 GND sg13_lv_nmos L=0.13u W=0.3u AS=0.057p
+ AD=0.0525p PS=0.68u PD=0.65u rfmode=0
M$811 RBL[31] RWL[10] \$953 GND sg13_lv_nmos L=0.13u W=0.3u AS=0.057p
+ AD=0.0525p PS=0.68u PD=0.65u rfmode=0
M$812 RBL[32] RWL[10] \$951 GND sg13_lv_nmos L=0.13u W=0.3u AS=0.057p
+ AD=0.0525p PS=0.68u PD=0.65u rfmode=0
M$813 RBL[33] RWL[10] \$948 GND sg13_lv_nmos L=0.13u W=0.3u AS=0.057p
+ AD=0.0525p PS=0.68u PD=0.65u rfmode=0
M$814 RBL[34] RWL[10] \$946 GND sg13_lv_nmos L=0.13u W=0.3u AS=0.057p
+ AD=0.0525p PS=0.68u PD=0.65u rfmode=0
M$815 RBL[35] RWL[10] \$943 GND sg13_lv_nmos L=0.13u W=0.3u AS=0.057p
+ AD=0.0525p PS=0.68u PD=0.65u rfmode=0
M$816 RBL[36] RWL[10] \$941 GND sg13_lv_nmos L=0.13u W=0.3u AS=0.057p
+ AD=0.0525p PS=0.68u PD=0.65u rfmode=0
M$817 RBL[37] RWL[10] \$938 GND sg13_lv_nmos L=0.13u W=0.3u AS=0.057p
+ AD=0.0525p PS=0.68u PD=0.65u rfmode=0
M$818 \$966 \$914 GND GND sg13_lv_nmos L=0.13u W=0.3u AS=0.0525p
+ AD=0.331736842105p PS=0.65u PD=2.24315789474u rfmode=0
M$819 \$967 \$915 GND GND sg13_lv_nmos L=0.13u W=0.3u AS=0.0525p
+ AD=0.331736842105p PS=0.65u PD=2.24315789474u rfmode=0
M$820 \$969 \$916 GND GND sg13_lv_nmos L=0.13u W=0.3u AS=0.0525p
+ AD=0.331736842105p PS=0.65u PD=2.24315789474u rfmode=0
M$821 \$971 \$917 GND GND sg13_lv_nmos L=0.13u W=0.3u AS=0.0525p
+ AD=0.331736842105p PS=0.65u PD=2.24315789474u rfmode=0
M$822 \$972 \$918 GND GND sg13_lv_nmos L=0.13u W=0.3u AS=0.0525p
+ AD=0.331736842105p PS=0.65u PD=2.24315789474u rfmode=0
M$823 \$970 \$919 GND GND sg13_lv_nmos L=0.13u W=0.3u AS=0.0525p
+ AD=0.331736842105p PS=0.65u PD=2.24315789474u rfmode=0
M$824 \$968 \$920 GND GND sg13_lv_nmos L=0.13u W=0.3u AS=0.0525p
+ AD=0.331736842105p PS=0.65u PD=2.24315789474u rfmode=0
M$825 \$965 \$921 GND GND sg13_lv_nmos L=0.13u W=0.3u AS=0.0525p
+ AD=0.331736842105p PS=0.65u PD=2.24315789474u rfmode=0
M$826 \$964 \$922 GND GND sg13_lv_nmos L=0.13u W=0.3u AS=0.0525p
+ AD=0.331736842105p PS=0.65u PD=2.24315789474u rfmode=0
M$827 \$961 \$923 GND GND sg13_lv_nmos L=0.13u W=0.3u AS=0.0525p
+ AD=0.331736842105p PS=0.65u PD=2.24315789474u rfmode=0
M$828 \$958 \$924 GND GND sg13_lv_nmos L=0.13u W=0.3u AS=0.0525p
+ AD=0.331736842105p PS=0.65u PD=2.24315789474u rfmode=0
M$829 \$956 \$925 GND GND sg13_lv_nmos L=0.13u W=0.3u AS=0.0525p
+ AD=0.331736842105p PS=0.65u PD=2.24315789474u rfmode=0
M$830 \$953 \$926 GND GND sg13_lv_nmos L=0.13u W=0.3u AS=0.0525p
+ AD=0.331736842105p PS=0.65u PD=2.24315789474u rfmode=0
M$831 \$951 \$927 GND GND sg13_lv_nmos L=0.13u W=0.3u AS=0.0525p
+ AD=0.331736842105p PS=0.65u PD=2.24315789474u rfmode=0
M$832 \$948 \$928 GND GND sg13_lv_nmos L=0.13u W=0.3u AS=0.0525p
+ AD=0.331736842105p PS=0.65u PD=2.24315789474u rfmode=0
M$833 \$946 \$929 GND GND sg13_lv_nmos L=0.13u W=0.3u AS=0.0525p
+ AD=0.331736842105p PS=0.65u PD=2.24315789474u rfmode=0
M$834 \$943 \$930 GND GND sg13_lv_nmos L=0.13u W=0.3u AS=0.0525p
+ AD=0.331736842105p PS=0.65u PD=2.24315789474u rfmode=0
M$835 \$941 \$931 GND GND sg13_lv_nmos L=0.13u W=0.3u AS=0.0525p
+ AD=0.331736842105p PS=0.65u PD=2.24315789474u rfmode=0
M$836 \$938 \$932 GND GND sg13_lv_nmos L=0.13u W=0.3u AS=0.0525p
+ AD=0.331736842105p PS=0.65u PD=2.24315789474u rfmode=0
M$837 GND \$973 \$1018 GND sg13_lv_nmos L=0.13u W=0.3u AS=0.331736842105p
+ AD=0.0525p PS=2.24315789474u PD=0.65u rfmode=0
M$838 GND \$974 \$1020 GND sg13_lv_nmos L=0.13u W=0.3u AS=0.331736842105p
+ AD=0.0525p PS=2.24315789474u PD=0.65u rfmode=0
M$839 GND \$975 \$1022 GND sg13_lv_nmos L=0.13u W=0.3u AS=0.331736842105p
+ AD=0.0525p PS=2.24315789474u PD=0.65u rfmode=0
M$840 GND \$976 \$1023 GND sg13_lv_nmos L=0.13u W=0.3u AS=0.331736842105p
+ AD=0.0525p PS=2.24315789474u PD=0.65u rfmode=0
M$841 GND \$977 \$1025 GND sg13_lv_nmos L=0.13u W=0.3u AS=0.331736842105p
+ AD=0.0525p PS=2.24315789474u PD=0.65u rfmode=0
M$842 GND \$978 \$1026 GND sg13_lv_nmos L=0.13u W=0.3u AS=0.331736842105p
+ AD=0.0525p PS=2.24315789474u PD=0.65u rfmode=0
M$843 GND \$979 \$1028 GND sg13_lv_nmos L=0.13u W=0.3u AS=0.331736842105p
+ AD=0.0525p PS=2.24315789474u PD=0.65u rfmode=0
M$844 GND \$980 \$1030 GND sg13_lv_nmos L=0.13u W=0.3u AS=0.331736842105p
+ AD=0.0525p PS=2.24315789474u PD=0.65u rfmode=0
M$845 GND \$981 \$1031 GND sg13_lv_nmos L=0.13u W=0.3u AS=0.331736842105p
+ AD=0.0525p PS=2.24315789474u PD=0.65u rfmode=0
M$846 GND \$982 \$1033 GND sg13_lv_nmos L=0.13u W=0.3u AS=0.331736842105p
+ AD=0.0525p PS=2.24315789474u PD=0.65u rfmode=0
M$847 GND \$983 \$1035 GND sg13_lv_nmos L=0.13u W=0.3u AS=0.331736842105p
+ AD=0.0525p PS=2.24315789474u PD=0.65u rfmode=0
M$848 GND \$984 \$1036 GND sg13_lv_nmos L=0.13u W=0.3u AS=0.331736842105p
+ AD=0.0525p PS=2.24315789474u PD=0.65u rfmode=0
M$849 GND \$985 \$1038 GND sg13_lv_nmos L=0.13u W=0.3u AS=0.331736842105p
+ AD=0.0525p PS=2.24315789474u PD=0.65u rfmode=0
M$850 GND \$986 \$1039 GND sg13_lv_nmos L=0.13u W=0.3u AS=0.331736842105p
+ AD=0.0525p PS=2.24315789474u PD=0.65u rfmode=0
M$851 GND \$987 \$1041 GND sg13_lv_nmos L=0.13u W=0.3u AS=0.331736842105p
+ AD=0.0525p PS=2.24315789474u PD=0.65u rfmode=0
M$852 GND \$988 \$1043 GND sg13_lv_nmos L=0.13u W=0.3u AS=0.331736842105p
+ AD=0.0525p PS=2.24315789474u PD=0.65u rfmode=0
M$853 GND \$989 \$1044 GND sg13_lv_nmos L=0.13u W=0.3u AS=0.331736842105p
+ AD=0.0525p PS=2.24315789474u PD=0.65u rfmode=0
M$854 GND \$990 \$1046 GND sg13_lv_nmos L=0.13u W=0.3u AS=0.331736842105p
+ AD=0.0525p PS=2.24315789474u PD=0.65u rfmode=0
M$855 GND \$991 \$1047 GND sg13_lv_nmos L=0.13u W=0.3u AS=0.331736842105p
+ AD=0.0525p PS=2.24315789474u PD=0.65u rfmode=0
M$856 \$1018 RWL[11] RBL[0] GND sg13_lv_nmos L=0.13u W=0.3u AS=0.0525p
+ AD=0.057p PS=0.65u PD=0.68u rfmode=0
M$857 \$1020 RWL[11] RBL[1] GND sg13_lv_nmos L=0.13u W=0.3u AS=0.0525p
+ AD=0.057p PS=0.65u PD=0.68u rfmode=0
M$858 \$1022 RWL[11] RBL[2] GND sg13_lv_nmos L=0.13u W=0.3u AS=0.0525p
+ AD=0.057p PS=0.65u PD=0.68u rfmode=0
M$859 \$1023 RWL[11] RBL[3] GND sg13_lv_nmos L=0.13u W=0.3u AS=0.0525p
+ AD=0.057p PS=0.65u PD=0.68u rfmode=0
M$860 \$1025 RWL[11] RBL[4] GND sg13_lv_nmos L=0.13u W=0.3u AS=0.0525p
+ AD=0.057p PS=0.65u PD=0.68u rfmode=0
M$861 \$1026 RWL[11] RBL[5] GND sg13_lv_nmos L=0.13u W=0.3u AS=0.0525p
+ AD=0.057p PS=0.65u PD=0.68u rfmode=0
M$862 \$1028 RWL[11] RBL[6] GND sg13_lv_nmos L=0.13u W=0.3u AS=0.0525p
+ AD=0.057p PS=0.65u PD=0.68u rfmode=0
M$863 \$1030 RWL[11] RBL[7] GND sg13_lv_nmos L=0.13u W=0.3u AS=0.0525p
+ AD=0.057p PS=0.65u PD=0.68u rfmode=0
M$864 \$1031 RWL[11] RBL[8] GND sg13_lv_nmos L=0.13u W=0.3u AS=0.0525p
+ AD=0.057p PS=0.65u PD=0.68u rfmode=0
M$865 \$1033 RWL[11] RBL[9] GND sg13_lv_nmos L=0.13u W=0.3u AS=0.0525p
+ AD=0.057p PS=0.65u PD=0.68u rfmode=0
M$866 \$1035 RWL[11] RBL[10] GND sg13_lv_nmos L=0.13u W=0.3u AS=0.0525p
+ AD=0.057p PS=0.65u PD=0.68u rfmode=0
M$867 \$1036 RWL[11] RBL[11] GND sg13_lv_nmos L=0.13u W=0.3u AS=0.0525p
+ AD=0.057p PS=0.65u PD=0.68u rfmode=0
M$868 \$1038 RWL[11] RBL[12] GND sg13_lv_nmos L=0.13u W=0.3u AS=0.0525p
+ AD=0.057p PS=0.65u PD=0.68u rfmode=0
M$869 \$1039 RWL[11] RBL[13] GND sg13_lv_nmos L=0.13u W=0.3u AS=0.0525p
+ AD=0.057p PS=0.65u PD=0.68u rfmode=0
M$870 \$1041 RWL[11] RBL[14] GND sg13_lv_nmos L=0.13u W=0.3u AS=0.0525p
+ AD=0.057p PS=0.65u PD=0.68u rfmode=0
M$871 \$1043 RWL[11] RBL[15] GND sg13_lv_nmos L=0.13u W=0.3u AS=0.0525p
+ AD=0.057p PS=0.65u PD=0.68u rfmode=0
M$872 \$1044 RWL[11] RBL[16] GND sg13_lv_nmos L=0.13u W=0.3u AS=0.0525p
+ AD=0.057p PS=0.65u PD=0.68u rfmode=0
M$873 \$1046 RWL[11] RBL[17] GND sg13_lv_nmos L=0.13u W=0.3u AS=0.0525p
+ AD=0.057p PS=0.65u PD=0.68u rfmode=0
M$874 \$1047 RWL[11] RBL[18] GND sg13_lv_nmos L=0.13u W=0.3u AS=0.0525p
+ AD=0.057p PS=0.65u PD=0.68u rfmode=0
M$875 RBL[0] RWL[12] \$1098 GND sg13_lv_nmos L=0.13u W=0.3u AS=0.057p
+ AD=0.0525p PS=0.68u PD=0.65u rfmode=0
M$876 RBL[1] RWL[12] \$1099 GND sg13_lv_nmos L=0.13u W=0.3u AS=0.057p
+ AD=0.0525p PS=0.68u PD=0.65u rfmode=0
M$877 RBL[2] RWL[12] \$1100 GND sg13_lv_nmos L=0.13u W=0.3u AS=0.057p
+ AD=0.0525p PS=0.68u PD=0.65u rfmode=0
M$878 RBL[3] RWL[12] \$1102 GND sg13_lv_nmos L=0.13u W=0.3u AS=0.057p
+ AD=0.0525p PS=0.68u PD=0.65u rfmode=0
M$879 RBL[4] RWL[12] \$1103 GND sg13_lv_nmos L=0.13u W=0.3u AS=0.057p
+ AD=0.0525p PS=0.68u PD=0.65u rfmode=0
M$880 RBL[5] RWL[12] \$1105 GND sg13_lv_nmos L=0.13u W=0.3u AS=0.057p
+ AD=0.0525p PS=0.68u PD=0.65u rfmode=0
M$881 RBL[6] RWL[12] \$1107 GND sg13_lv_nmos L=0.13u W=0.3u AS=0.057p
+ AD=0.0525p PS=0.68u PD=0.65u rfmode=0
M$882 RBL[7] RWL[12] \$1108 GND sg13_lv_nmos L=0.13u W=0.3u AS=0.057p
+ AD=0.0525p PS=0.68u PD=0.65u rfmode=0
M$883 RBL[8] RWL[12] \$1110 GND sg13_lv_nmos L=0.13u W=0.3u AS=0.057p
+ AD=0.0525p PS=0.68u PD=0.65u rfmode=0
M$884 RBL[9] RWL[12] \$1112 GND sg13_lv_nmos L=0.13u W=0.3u AS=0.057p
+ AD=0.0525p PS=0.68u PD=0.65u rfmode=0
M$885 RBL[10] RWL[12] \$1113 GND sg13_lv_nmos L=0.13u W=0.3u AS=0.057p
+ AD=0.0525p PS=0.68u PD=0.65u rfmode=0
M$886 RBL[11] RWL[12] \$1115 GND sg13_lv_nmos L=0.13u W=0.3u AS=0.057p
+ AD=0.0525p PS=0.68u PD=0.65u rfmode=0
M$887 RBL[12] RWL[12] \$1117 GND sg13_lv_nmos L=0.13u W=0.3u AS=0.057p
+ AD=0.0525p PS=0.68u PD=0.65u rfmode=0
M$888 RBL[13] RWL[12] \$1118 GND sg13_lv_nmos L=0.13u W=0.3u AS=0.057p
+ AD=0.0525p PS=0.68u PD=0.65u rfmode=0
M$889 RBL[14] RWL[12] \$1120 GND sg13_lv_nmos L=0.13u W=0.3u AS=0.057p
+ AD=0.0525p PS=0.68u PD=0.65u rfmode=0
M$890 RBL[15] RWL[12] \$1121 GND sg13_lv_nmos L=0.13u W=0.3u AS=0.057p
+ AD=0.0525p PS=0.68u PD=0.65u rfmode=0
M$891 RBL[16] RWL[12] \$1123 GND sg13_lv_nmos L=0.13u W=0.3u AS=0.057p
+ AD=0.0525p PS=0.68u PD=0.65u rfmode=0
M$892 RBL[17] RWL[12] \$1125 GND sg13_lv_nmos L=0.13u W=0.3u AS=0.057p
+ AD=0.0525p PS=0.68u PD=0.65u rfmode=0
M$893 RBL[18] RWL[12] \$1126 GND sg13_lv_nmos L=0.13u W=0.3u AS=0.057p
+ AD=0.0525p PS=0.68u PD=0.65u rfmode=0
M$894 \$1098 \$1058 GND GND sg13_lv_nmos L=0.13u W=0.3u AS=0.0525p
+ AD=0.331736842105p PS=0.65u PD=2.24315789474u rfmode=0
M$895 \$1099 \$1059 GND GND sg13_lv_nmos L=0.13u W=0.3u AS=0.0525p
+ AD=0.331736842105p PS=0.65u PD=2.24315789474u rfmode=0
M$896 \$1100 \$1060 GND GND sg13_lv_nmos L=0.13u W=0.3u AS=0.0525p
+ AD=0.331736842105p PS=0.65u PD=2.24315789474u rfmode=0
M$897 \$1102 \$1061 GND GND sg13_lv_nmos L=0.13u W=0.3u AS=0.0525p
+ AD=0.331736842105p PS=0.65u PD=2.24315789474u rfmode=0
M$898 \$1103 \$1062 GND GND sg13_lv_nmos L=0.13u W=0.3u AS=0.0525p
+ AD=0.331736842105p PS=0.65u PD=2.24315789474u rfmode=0
M$899 \$1105 \$1063 GND GND sg13_lv_nmos L=0.13u W=0.3u AS=0.0525p
+ AD=0.331736842105p PS=0.65u PD=2.24315789474u rfmode=0
M$900 \$1107 \$1064 GND GND sg13_lv_nmos L=0.13u W=0.3u AS=0.0525p
+ AD=0.331736842105p PS=0.65u PD=2.24315789474u rfmode=0
M$901 \$1108 \$1065 GND GND sg13_lv_nmos L=0.13u W=0.3u AS=0.0525p
+ AD=0.331736842105p PS=0.65u PD=2.24315789474u rfmode=0
M$902 \$1110 \$1066 GND GND sg13_lv_nmos L=0.13u W=0.3u AS=0.0525p
+ AD=0.331736842105p PS=0.65u PD=2.24315789474u rfmode=0
M$903 \$1112 \$1067 GND GND sg13_lv_nmos L=0.13u W=0.3u AS=0.0525p
+ AD=0.331736842105p PS=0.65u PD=2.24315789474u rfmode=0
M$904 \$1113 \$1068 GND GND sg13_lv_nmos L=0.13u W=0.3u AS=0.0525p
+ AD=0.331736842105p PS=0.65u PD=2.24315789474u rfmode=0
M$905 \$1115 \$1069 GND GND sg13_lv_nmos L=0.13u W=0.3u AS=0.0525p
+ AD=0.331736842105p PS=0.65u PD=2.24315789474u rfmode=0
M$906 \$1117 \$1070 GND GND sg13_lv_nmos L=0.13u W=0.3u AS=0.0525p
+ AD=0.331736842105p PS=0.65u PD=2.24315789474u rfmode=0
M$907 \$1118 \$1071 GND GND sg13_lv_nmos L=0.13u W=0.3u AS=0.0525p
+ AD=0.331736842105p PS=0.65u PD=2.24315789474u rfmode=0
M$908 \$1120 \$1072 GND GND sg13_lv_nmos L=0.13u W=0.3u AS=0.0525p
+ AD=0.331736842105p PS=0.65u PD=2.24315789474u rfmode=0
M$909 \$1121 \$1073 GND GND sg13_lv_nmos L=0.13u W=0.3u AS=0.0525p
+ AD=0.331736842105p PS=0.65u PD=2.24315789474u rfmode=0
M$910 \$1123 \$1074 GND GND sg13_lv_nmos L=0.13u W=0.3u AS=0.0525p
+ AD=0.331736842105p PS=0.65u PD=2.24315789474u rfmode=0
M$911 \$1125 \$1075 GND GND sg13_lv_nmos L=0.13u W=0.3u AS=0.0525p
+ AD=0.331736842105p PS=0.65u PD=2.24315789474u rfmode=0
M$912 \$1126 \$1076 GND GND sg13_lv_nmos L=0.13u W=0.3u AS=0.0525p
+ AD=0.331736842105p PS=0.65u PD=2.24315789474u rfmode=0
M$913 GND \$992 \$1049 GND sg13_lv_nmos L=0.13u W=0.3u AS=0.331736842105p
+ AD=0.0525p PS=2.24315789474u PD=0.65u rfmode=0
M$914 GND \$993 \$1051 GND sg13_lv_nmos L=0.13u W=0.3u AS=0.331736842105p
+ AD=0.0525p PS=2.24315789474u PD=0.65u rfmode=0
M$915 GND \$994 \$1053 GND sg13_lv_nmos L=0.13u W=0.3u AS=0.331736842105p
+ AD=0.0525p PS=2.24315789474u PD=0.65u rfmode=0
M$916 GND \$995 \$1054 GND sg13_lv_nmos L=0.13u W=0.3u AS=0.331736842105p
+ AD=0.0525p PS=2.24315789474u PD=0.65u rfmode=0
M$917 GND \$996 \$1052 GND sg13_lv_nmos L=0.13u W=0.3u AS=0.331736842105p
+ AD=0.0525p PS=2.24315789474u PD=0.65u rfmode=0
M$918 GND \$997 \$1050 GND sg13_lv_nmos L=0.13u W=0.3u AS=0.331736842105p
+ AD=0.0525p PS=2.24315789474u PD=0.65u rfmode=0
M$919 GND \$998 \$1048 GND sg13_lv_nmos L=0.13u W=0.3u AS=0.331736842105p
+ AD=0.0525p PS=2.24315789474u PD=0.65u rfmode=0
M$920 GND \$999 \$1045 GND sg13_lv_nmos L=0.13u W=0.3u AS=0.331736842105p
+ AD=0.0525p PS=2.24315789474u PD=0.65u rfmode=0
M$921 GND \$1000 \$1042 GND sg13_lv_nmos L=0.13u W=0.3u AS=0.331736842105p
+ AD=0.0525p PS=2.24315789474u PD=0.65u rfmode=0
M$922 GND \$1001 \$1040 GND sg13_lv_nmos L=0.13u W=0.3u AS=0.331736842105p
+ AD=0.0525p PS=2.24315789474u PD=0.65u rfmode=0
M$923 GND \$1002 \$1037 GND sg13_lv_nmos L=0.13u W=0.3u AS=0.331736842105p
+ AD=0.0525p PS=2.24315789474u PD=0.65u rfmode=0
M$924 GND \$1003 \$1034 GND sg13_lv_nmos L=0.13u W=0.3u AS=0.331736842105p
+ AD=0.0525p PS=2.24315789474u PD=0.65u rfmode=0
M$925 GND \$1004 \$1032 GND sg13_lv_nmos L=0.13u W=0.3u AS=0.331736842105p
+ AD=0.0525p PS=2.24315789474u PD=0.65u rfmode=0
M$926 GND \$1005 \$1029 GND sg13_lv_nmos L=0.13u W=0.3u AS=0.331736842105p
+ AD=0.0525p PS=2.24315789474u PD=0.65u rfmode=0
M$927 GND \$1006 \$1027 GND sg13_lv_nmos L=0.13u W=0.3u AS=0.331736842105p
+ AD=0.0525p PS=2.24315789474u PD=0.65u rfmode=0
M$928 GND \$1007 \$1024 GND sg13_lv_nmos L=0.13u W=0.3u AS=0.331736842105p
+ AD=0.0525p PS=2.24315789474u PD=0.65u rfmode=0
M$929 GND \$1008 \$1021 GND sg13_lv_nmos L=0.13u W=0.3u AS=0.331736842105p
+ AD=0.0525p PS=2.24315789474u PD=0.65u rfmode=0
M$930 GND \$1009 \$1019 GND sg13_lv_nmos L=0.13u W=0.3u AS=0.331736842105p
+ AD=0.0525p PS=2.24315789474u PD=0.65u rfmode=0
M$931 GND \$1010 \$1017 GND sg13_lv_nmos L=0.13u W=0.3u AS=0.331736842105p
+ AD=0.0525p PS=2.24315789474u PD=0.65u rfmode=0
M$932 \$1049 RWL[11] RBL[19] GND sg13_lv_nmos L=0.13u W=0.3u AS=0.0525p
+ AD=0.057p PS=0.65u PD=0.68u rfmode=0
M$933 \$1051 RWL[11] RBL[20] GND sg13_lv_nmos L=0.13u W=0.3u AS=0.0525p
+ AD=0.057p PS=0.65u PD=0.68u rfmode=0
M$934 \$1053 RWL[11] RBL[21] GND sg13_lv_nmos L=0.13u W=0.3u AS=0.0525p
+ AD=0.057p PS=0.65u PD=0.68u rfmode=0
M$935 \$1054 RWL[11] RBL[22] GND sg13_lv_nmos L=0.13u W=0.3u AS=0.0525p
+ AD=0.057p PS=0.65u PD=0.68u rfmode=0
M$936 \$1052 RWL[11] RBL[23] GND sg13_lv_nmos L=0.13u W=0.3u AS=0.0525p
+ AD=0.057p PS=0.65u PD=0.68u rfmode=0
M$937 \$1050 RWL[11] RBL[24] GND sg13_lv_nmos L=0.13u W=0.3u AS=0.0525p
+ AD=0.057p PS=0.65u PD=0.68u rfmode=0
M$938 \$1048 RWL[11] RBL[25] GND sg13_lv_nmos L=0.13u W=0.3u AS=0.0525p
+ AD=0.057p PS=0.65u PD=0.68u rfmode=0
M$939 \$1045 RWL[11] RBL[26] GND sg13_lv_nmos L=0.13u W=0.3u AS=0.0525p
+ AD=0.057p PS=0.65u PD=0.68u rfmode=0
M$940 \$1042 RWL[11] RBL[27] GND sg13_lv_nmos L=0.13u W=0.3u AS=0.0525p
+ AD=0.057p PS=0.65u PD=0.68u rfmode=0
M$941 \$1040 RWL[11] RBL[28] GND sg13_lv_nmos L=0.13u W=0.3u AS=0.0525p
+ AD=0.057p PS=0.65u PD=0.68u rfmode=0
M$942 \$1037 RWL[11] RBL[29] GND sg13_lv_nmos L=0.13u W=0.3u AS=0.0525p
+ AD=0.057p PS=0.65u PD=0.68u rfmode=0
M$943 \$1034 RWL[11] RBL[30] GND sg13_lv_nmos L=0.13u W=0.3u AS=0.0525p
+ AD=0.057p PS=0.65u PD=0.68u rfmode=0
M$944 \$1032 RWL[11] RBL[31] GND sg13_lv_nmos L=0.13u W=0.3u AS=0.0525p
+ AD=0.057p PS=0.65u PD=0.68u rfmode=0
M$945 \$1029 RWL[11] RBL[32] GND sg13_lv_nmos L=0.13u W=0.3u AS=0.0525p
+ AD=0.057p PS=0.65u PD=0.68u rfmode=0
M$946 \$1027 RWL[11] RBL[33] GND sg13_lv_nmos L=0.13u W=0.3u AS=0.0525p
+ AD=0.057p PS=0.65u PD=0.68u rfmode=0
M$947 \$1024 RWL[11] RBL[34] GND sg13_lv_nmos L=0.13u W=0.3u AS=0.0525p
+ AD=0.057p PS=0.65u PD=0.68u rfmode=0
M$948 \$1021 RWL[11] RBL[35] GND sg13_lv_nmos L=0.13u W=0.3u AS=0.0525p
+ AD=0.057p PS=0.65u PD=0.68u rfmode=0
M$949 \$1019 RWL[11] RBL[36] GND sg13_lv_nmos L=0.13u W=0.3u AS=0.0525p
+ AD=0.057p PS=0.65u PD=0.68u rfmode=0
M$950 \$1017 RWL[11] RBL[37] GND sg13_lv_nmos L=0.13u W=0.3u AS=0.0525p
+ AD=0.057p PS=0.65u PD=0.68u rfmode=0
M$951 RBL[19] RWL[12] \$1129 GND sg13_lv_nmos L=0.13u W=0.3u AS=0.057p
+ AD=0.0525p PS=0.68u PD=0.65u rfmode=0
M$952 RBL[20] RWL[12] \$1130 GND sg13_lv_nmos L=0.13u W=0.3u AS=0.057p
+ AD=0.0525p PS=0.68u PD=0.65u rfmode=0
M$953 RBL[21] RWL[12] \$1132 GND sg13_lv_nmos L=0.13u W=0.3u AS=0.057p
+ AD=0.0525p PS=0.68u PD=0.65u rfmode=0
M$954 RBL[22] RWL[12] \$1134 GND sg13_lv_nmos L=0.13u W=0.3u AS=0.057p
+ AD=0.0525p PS=0.68u PD=0.65u rfmode=0
M$955 RBL[23] RWL[12] \$1135 GND sg13_lv_nmos L=0.13u W=0.3u AS=0.057p
+ AD=0.0525p PS=0.68u PD=0.65u rfmode=0
M$956 RBL[24] RWL[12] \$1133 GND sg13_lv_nmos L=0.13u W=0.3u AS=0.057p
+ AD=0.0525p PS=0.68u PD=0.65u rfmode=0
M$957 RBL[25] RWL[12] \$1131 GND sg13_lv_nmos L=0.13u W=0.3u AS=0.057p
+ AD=0.0525p PS=0.68u PD=0.65u rfmode=0
M$958 RBL[26] RWL[12] \$1128 GND sg13_lv_nmos L=0.13u W=0.3u AS=0.057p
+ AD=0.0525p PS=0.68u PD=0.65u rfmode=0
M$959 RBL[27] RWL[12] \$1127 GND sg13_lv_nmos L=0.13u W=0.3u AS=0.057p
+ AD=0.0525p PS=0.68u PD=0.65u rfmode=0
M$960 RBL[28] RWL[12] \$1124 GND sg13_lv_nmos L=0.13u W=0.3u AS=0.057p
+ AD=0.0525p PS=0.68u PD=0.65u rfmode=0
M$961 RBL[29] RWL[12] \$1122 GND sg13_lv_nmos L=0.13u W=0.3u AS=0.057p
+ AD=0.0525p PS=0.68u PD=0.65u rfmode=0
M$962 RBL[30] RWL[12] \$1119 GND sg13_lv_nmos L=0.13u W=0.3u AS=0.057p
+ AD=0.0525p PS=0.68u PD=0.65u rfmode=0
M$963 RBL[31] RWL[12] \$1116 GND sg13_lv_nmos L=0.13u W=0.3u AS=0.057p
+ AD=0.0525p PS=0.68u PD=0.65u rfmode=0
M$964 RBL[32] RWL[12] \$1114 GND sg13_lv_nmos L=0.13u W=0.3u AS=0.057p
+ AD=0.0525p PS=0.68u PD=0.65u rfmode=0
M$965 RBL[33] RWL[12] \$1111 GND sg13_lv_nmos L=0.13u W=0.3u AS=0.057p
+ AD=0.0525p PS=0.68u PD=0.65u rfmode=0
M$966 RBL[34] RWL[12] \$1109 GND sg13_lv_nmos L=0.13u W=0.3u AS=0.057p
+ AD=0.0525p PS=0.68u PD=0.65u rfmode=0
M$967 RBL[35] RWL[12] \$1106 GND sg13_lv_nmos L=0.13u W=0.3u AS=0.057p
+ AD=0.0525p PS=0.68u PD=0.65u rfmode=0
M$968 RBL[36] RWL[12] \$1104 GND sg13_lv_nmos L=0.13u W=0.3u AS=0.057p
+ AD=0.0525p PS=0.68u PD=0.65u rfmode=0
M$969 RBL[37] RWL[12] \$1101 GND sg13_lv_nmos L=0.13u W=0.3u AS=0.057p
+ AD=0.0525p PS=0.68u PD=0.65u rfmode=0
M$970 \$1129 \$1077 GND GND sg13_lv_nmos L=0.13u W=0.3u AS=0.0525p
+ AD=0.331736842105p PS=0.65u PD=2.24315789474u rfmode=0
M$971 \$1130 \$1078 GND GND sg13_lv_nmos L=0.13u W=0.3u AS=0.0525p
+ AD=0.331736842105p PS=0.65u PD=2.24315789474u rfmode=0
M$972 \$1132 \$1079 GND GND sg13_lv_nmos L=0.13u W=0.3u AS=0.0525p
+ AD=0.331736842105p PS=0.65u PD=2.24315789474u rfmode=0
M$973 \$1134 \$1080 GND GND sg13_lv_nmos L=0.13u W=0.3u AS=0.0525p
+ AD=0.331736842105p PS=0.65u PD=2.24315789474u rfmode=0
M$974 \$1135 \$1081 GND GND sg13_lv_nmos L=0.13u W=0.3u AS=0.0525p
+ AD=0.331736842105p PS=0.65u PD=2.24315789474u rfmode=0
M$975 \$1133 \$1082 GND GND sg13_lv_nmos L=0.13u W=0.3u AS=0.0525p
+ AD=0.331736842105p PS=0.65u PD=2.24315789474u rfmode=0
M$976 \$1131 \$1083 GND GND sg13_lv_nmos L=0.13u W=0.3u AS=0.0525p
+ AD=0.331736842105p PS=0.65u PD=2.24315789474u rfmode=0
M$977 \$1128 \$1084 GND GND sg13_lv_nmos L=0.13u W=0.3u AS=0.0525p
+ AD=0.331736842105p PS=0.65u PD=2.24315789474u rfmode=0
M$978 \$1127 \$1085 GND GND sg13_lv_nmos L=0.13u W=0.3u AS=0.0525p
+ AD=0.331736842105p PS=0.65u PD=2.24315789474u rfmode=0
M$979 \$1124 \$1086 GND GND sg13_lv_nmos L=0.13u W=0.3u AS=0.0525p
+ AD=0.331736842105p PS=0.65u PD=2.24315789474u rfmode=0
M$980 \$1122 \$1087 GND GND sg13_lv_nmos L=0.13u W=0.3u AS=0.0525p
+ AD=0.331736842105p PS=0.65u PD=2.24315789474u rfmode=0
M$981 \$1119 \$1088 GND GND sg13_lv_nmos L=0.13u W=0.3u AS=0.0525p
+ AD=0.331736842105p PS=0.65u PD=2.24315789474u rfmode=0
M$982 \$1116 \$1089 GND GND sg13_lv_nmos L=0.13u W=0.3u AS=0.0525p
+ AD=0.331736842105p PS=0.65u PD=2.24315789474u rfmode=0
M$983 \$1114 \$1090 GND GND sg13_lv_nmos L=0.13u W=0.3u AS=0.0525p
+ AD=0.331736842105p PS=0.65u PD=2.24315789474u rfmode=0
M$984 \$1111 \$1091 GND GND sg13_lv_nmos L=0.13u W=0.3u AS=0.0525p
+ AD=0.331736842105p PS=0.65u PD=2.24315789474u rfmode=0
M$985 \$1109 \$1092 GND GND sg13_lv_nmos L=0.13u W=0.3u AS=0.0525p
+ AD=0.331736842105p PS=0.65u PD=2.24315789474u rfmode=0
M$986 \$1106 \$1093 GND GND sg13_lv_nmos L=0.13u W=0.3u AS=0.0525p
+ AD=0.331736842105p PS=0.65u PD=2.24315789474u rfmode=0
M$987 \$1104 \$1094 GND GND sg13_lv_nmos L=0.13u W=0.3u AS=0.0525p
+ AD=0.331736842105p PS=0.65u PD=2.24315789474u rfmode=0
M$988 \$1101 \$1095 GND GND sg13_lv_nmos L=0.13u W=0.3u AS=0.0525p
+ AD=0.331736842105p PS=0.65u PD=2.24315789474u rfmode=0
M$989 GND \$1136 \$1181 GND sg13_lv_nmos L=0.13u W=0.3u AS=0.331736842105p
+ AD=0.0525p PS=2.24315789474u PD=0.65u rfmode=0
M$990 GND \$1137 \$1183 GND sg13_lv_nmos L=0.13u W=0.3u AS=0.331736842105p
+ AD=0.0525p PS=2.24315789474u PD=0.65u rfmode=0
M$991 GND \$1138 \$1185 GND sg13_lv_nmos L=0.13u W=0.3u AS=0.331736842105p
+ AD=0.0525p PS=2.24315789474u PD=0.65u rfmode=0
M$992 GND \$1139 \$1186 GND sg13_lv_nmos L=0.13u W=0.3u AS=0.331736842105p
+ AD=0.0525p PS=2.24315789474u PD=0.65u rfmode=0
M$993 GND \$1140 \$1188 GND sg13_lv_nmos L=0.13u W=0.3u AS=0.331736842105p
+ AD=0.0525p PS=2.24315789474u PD=0.65u rfmode=0
M$994 GND \$1141 \$1189 GND sg13_lv_nmos L=0.13u W=0.3u AS=0.331736842105p
+ AD=0.0525p PS=2.24315789474u PD=0.65u rfmode=0
M$995 GND \$1142 \$1191 GND sg13_lv_nmos L=0.13u W=0.3u AS=0.331736842105p
+ AD=0.0525p PS=2.24315789474u PD=0.65u rfmode=0
M$996 GND \$1143 \$1193 GND sg13_lv_nmos L=0.13u W=0.3u AS=0.331736842105p
+ AD=0.0525p PS=2.24315789474u PD=0.65u rfmode=0
M$997 GND \$1144 \$1194 GND sg13_lv_nmos L=0.13u W=0.3u AS=0.331736842105p
+ AD=0.0525p PS=2.24315789474u PD=0.65u rfmode=0
M$998 GND \$1145 \$1196 GND sg13_lv_nmos L=0.13u W=0.3u AS=0.331736842105p
+ AD=0.0525p PS=2.24315789474u PD=0.65u rfmode=0
M$999 GND \$1146 \$1197 GND sg13_lv_nmos L=0.13u W=0.3u AS=0.331736842105p
+ AD=0.0525p PS=2.24315789474u PD=0.65u rfmode=0
M$1000 GND \$1147 \$1199 GND sg13_lv_nmos L=0.13u W=0.3u AS=0.331736842105p
+ AD=0.0525p PS=2.24315789474u PD=0.65u rfmode=0
M$1001 GND \$1148 \$1201 GND sg13_lv_nmos L=0.13u W=0.3u AS=0.331736842105p
+ AD=0.0525p PS=2.24315789474u PD=0.65u rfmode=0
M$1002 GND \$1149 \$1202 GND sg13_lv_nmos L=0.13u W=0.3u AS=0.331736842105p
+ AD=0.0525p PS=2.24315789474u PD=0.65u rfmode=0
M$1003 GND \$1150 \$1204 GND sg13_lv_nmos L=0.13u W=0.3u AS=0.331736842105p
+ AD=0.0525p PS=2.24315789474u PD=0.65u rfmode=0
M$1004 GND \$1151 \$1206 GND sg13_lv_nmos L=0.13u W=0.3u AS=0.331736842105p
+ AD=0.0525p PS=2.24315789474u PD=0.65u rfmode=0
M$1005 GND \$1152 \$1207 GND sg13_lv_nmos L=0.13u W=0.3u AS=0.331736842105p
+ AD=0.0525p PS=2.24315789474u PD=0.65u rfmode=0
M$1006 GND \$1153 \$1209 GND sg13_lv_nmos L=0.13u W=0.3u AS=0.331736842105p
+ AD=0.0525p PS=2.24315789474u PD=0.65u rfmode=0
M$1007 GND \$1154 \$1210 GND sg13_lv_nmos L=0.13u W=0.3u AS=0.331736842105p
+ AD=0.0525p PS=2.24315789474u PD=0.65u rfmode=0
M$1008 \$1181 RWL[13] RBL[0] GND sg13_lv_nmos L=0.13u W=0.3u AS=0.0525p
+ AD=0.057p PS=0.65u PD=0.68u rfmode=0
M$1009 \$1183 RWL[13] RBL[1] GND sg13_lv_nmos L=0.13u W=0.3u AS=0.0525p
+ AD=0.057p PS=0.65u PD=0.68u rfmode=0
M$1010 \$1185 RWL[13] RBL[2] GND sg13_lv_nmos L=0.13u W=0.3u AS=0.0525p
+ AD=0.057p PS=0.65u PD=0.68u rfmode=0
M$1011 \$1186 RWL[13] RBL[3] GND sg13_lv_nmos L=0.13u W=0.3u AS=0.0525p
+ AD=0.057p PS=0.65u PD=0.68u rfmode=0
M$1012 \$1188 RWL[13] RBL[4] GND sg13_lv_nmos L=0.13u W=0.3u AS=0.0525p
+ AD=0.057p PS=0.65u PD=0.68u rfmode=0
M$1013 \$1189 RWL[13] RBL[5] GND sg13_lv_nmos L=0.13u W=0.3u AS=0.0525p
+ AD=0.057p PS=0.65u PD=0.68u rfmode=0
M$1014 \$1191 RWL[13] RBL[6] GND sg13_lv_nmos L=0.13u W=0.3u AS=0.0525p
+ AD=0.057p PS=0.65u PD=0.68u rfmode=0
M$1015 \$1193 RWL[13] RBL[7] GND sg13_lv_nmos L=0.13u W=0.3u AS=0.0525p
+ AD=0.057p PS=0.65u PD=0.68u rfmode=0
M$1016 \$1194 RWL[13] RBL[8] GND sg13_lv_nmos L=0.13u W=0.3u AS=0.0525p
+ AD=0.057p PS=0.65u PD=0.68u rfmode=0
M$1017 \$1196 RWL[13] RBL[9] GND sg13_lv_nmos L=0.13u W=0.3u AS=0.0525p
+ AD=0.057p PS=0.65u PD=0.68u rfmode=0
M$1018 \$1197 RWL[13] RBL[10] GND sg13_lv_nmos L=0.13u W=0.3u AS=0.0525p
+ AD=0.057p PS=0.65u PD=0.68u rfmode=0
M$1019 \$1199 RWL[13] RBL[11] GND sg13_lv_nmos L=0.13u W=0.3u AS=0.0525p
+ AD=0.057p PS=0.65u PD=0.68u rfmode=0
M$1020 \$1201 RWL[13] RBL[12] GND sg13_lv_nmos L=0.13u W=0.3u AS=0.0525p
+ AD=0.057p PS=0.65u PD=0.68u rfmode=0
M$1021 \$1202 RWL[13] RBL[13] GND sg13_lv_nmos L=0.13u W=0.3u AS=0.0525p
+ AD=0.057p PS=0.65u PD=0.68u rfmode=0
M$1022 \$1204 RWL[13] RBL[14] GND sg13_lv_nmos L=0.13u W=0.3u AS=0.0525p
+ AD=0.057p PS=0.65u PD=0.68u rfmode=0
M$1023 \$1206 RWL[13] RBL[15] GND sg13_lv_nmos L=0.13u W=0.3u AS=0.0525p
+ AD=0.057p PS=0.65u PD=0.68u rfmode=0
M$1024 \$1207 RWL[13] RBL[16] GND sg13_lv_nmos L=0.13u W=0.3u AS=0.0525p
+ AD=0.057p PS=0.65u PD=0.68u rfmode=0
M$1025 \$1209 RWL[13] RBL[17] GND sg13_lv_nmos L=0.13u W=0.3u AS=0.0525p
+ AD=0.057p PS=0.65u PD=0.68u rfmode=0
M$1026 \$1210 RWL[13] RBL[18] GND sg13_lv_nmos L=0.13u W=0.3u AS=0.0525p
+ AD=0.057p PS=0.65u PD=0.68u rfmode=0
M$1027 RBL[0] RWL[14] \$1261 GND sg13_lv_nmos L=0.13u W=0.3u AS=0.057p
+ AD=0.0525p PS=0.68u PD=0.65u rfmode=0
M$1028 RBL[1] RWL[14] \$1262 GND sg13_lv_nmos L=0.13u W=0.3u AS=0.057p
+ AD=0.0525p PS=0.68u PD=0.65u rfmode=0
M$1029 RBL[2] RWL[14] \$1263 GND sg13_lv_nmos L=0.13u W=0.3u AS=0.057p
+ AD=0.0525p PS=0.68u PD=0.65u rfmode=0
M$1030 RBL[3] RWL[14] \$1265 GND sg13_lv_nmos L=0.13u W=0.3u AS=0.057p
+ AD=0.0525p PS=0.68u PD=0.65u rfmode=0
M$1031 RBL[4] RWL[14] \$1266 GND sg13_lv_nmos L=0.13u W=0.3u AS=0.057p
+ AD=0.0525p PS=0.68u PD=0.65u rfmode=0
M$1032 RBL[5] RWL[14] \$1268 GND sg13_lv_nmos L=0.13u W=0.3u AS=0.057p
+ AD=0.0525p PS=0.68u PD=0.65u rfmode=0
M$1033 RBL[6] RWL[14] \$1270 GND sg13_lv_nmos L=0.13u W=0.3u AS=0.057p
+ AD=0.0525p PS=0.68u PD=0.65u rfmode=0
M$1034 RBL[7] RWL[14] \$1271 GND sg13_lv_nmos L=0.13u W=0.3u AS=0.057p
+ AD=0.0525p PS=0.68u PD=0.65u rfmode=0
M$1035 RBL[8] RWL[14] \$1273 GND sg13_lv_nmos L=0.13u W=0.3u AS=0.057p
+ AD=0.0525p PS=0.68u PD=0.65u rfmode=0
M$1036 RBL[9] RWL[14] \$1275 GND sg13_lv_nmos L=0.13u W=0.3u AS=0.057p
+ AD=0.0525p PS=0.68u PD=0.65u rfmode=0
M$1037 RBL[10] RWL[14] \$1277 GND sg13_lv_nmos L=0.13u W=0.3u AS=0.057p
+ AD=0.0525p PS=0.68u PD=0.65u rfmode=0
M$1038 RBL[11] RWL[14] \$1278 GND sg13_lv_nmos L=0.13u W=0.3u AS=0.057p
+ AD=0.0525p PS=0.68u PD=0.65u rfmode=0
M$1039 RBL[12] RWL[14] \$1279 GND sg13_lv_nmos L=0.13u W=0.3u AS=0.057p
+ AD=0.0525p PS=0.68u PD=0.65u rfmode=0
M$1040 RBL[13] RWL[14] \$1281 GND sg13_lv_nmos L=0.13u W=0.3u AS=0.057p
+ AD=0.0525p PS=0.68u PD=0.65u rfmode=0
M$1041 RBL[14] RWL[14] \$1283 GND sg13_lv_nmos L=0.13u W=0.3u AS=0.057p
+ AD=0.0525p PS=0.68u PD=0.65u rfmode=0
M$1042 RBL[15] RWL[14] \$1284 GND sg13_lv_nmos L=0.13u W=0.3u AS=0.057p
+ AD=0.0525p PS=0.68u PD=0.65u rfmode=0
M$1043 RBL[16] RWL[14] \$1286 GND sg13_lv_nmos L=0.13u W=0.3u AS=0.057p
+ AD=0.0525p PS=0.68u PD=0.65u rfmode=0
M$1044 RBL[17] RWL[14] \$1288 GND sg13_lv_nmos L=0.13u W=0.3u AS=0.057p
+ AD=0.0525p PS=0.68u PD=0.65u rfmode=0
M$1045 RBL[18] RWL[14] \$1289 GND sg13_lv_nmos L=0.13u W=0.3u AS=0.057p
+ AD=0.0525p PS=0.68u PD=0.65u rfmode=0
M$1046 \$1261 \$1221 GND GND sg13_lv_nmos L=0.13u W=0.3u AS=0.0525p
+ AD=0.331736842105p PS=0.65u PD=2.24315789474u rfmode=0
M$1047 \$1262 \$1222 GND GND sg13_lv_nmos L=0.13u W=0.3u AS=0.0525p
+ AD=0.331736842105p PS=0.65u PD=2.24315789474u rfmode=0
M$1048 \$1263 \$1223 GND GND sg13_lv_nmos L=0.13u W=0.3u AS=0.0525p
+ AD=0.331736842105p PS=0.65u PD=2.24315789474u rfmode=0
M$1049 \$1265 \$1224 GND GND sg13_lv_nmos L=0.13u W=0.3u AS=0.0525p
+ AD=0.331736842105p PS=0.65u PD=2.24315789474u rfmode=0
M$1050 \$1266 \$1225 GND GND sg13_lv_nmos L=0.13u W=0.3u AS=0.0525p
+ AD=0.331736842105p PS=0.65u PD=2.24315789474u rfmode=0
M$1051 \$1268 \$1226 GND GND sg13_lv_nmos L=0.13u W=0.3u AS=0.0525p
+ AD=0.331736842105p PS=0.65u PD=2.24315789474u rfmode=0
M$1052 \$1270 \$1227 GND GND sg13_lv_nmos L=0.13u W=0.3u AS=0.0525p
+ AD=0.331736842105p PS=0.65u PD=2.24315789474u rfmode=0
M$1053 \$1271 \$1228 GND GND sg13_lv_nmos L=0.13u W=0.3u AS=0.0525p
+ AD=0.331736842105p PS=0.65u PD=2.24315789474u rfmode=0
M$1054 \$1273 \$1229 GND GND sg13_lv_nmos L=0.13u W=0.3u AS=0.0525p
+ AD=0.331736842105p PS=0.65u PD=2.24315789474u rfmode=0
M$1055 \$1275 \$1230 GND GND sg13_lv_nmos L=0.13u W=0.3u AS=0.0525p
+ AD=0.331736842105p PS=0.65u PD=2.24315789474u rfmode=0
M$1056 \$1277 \$1231 GND GND sg13_lv_nmos L=0.13u W=0.3u AS=0.0525p
+ AD=0.331736842105p PS=0.65u PD=2.24315789474u rfmode=0
M$1057 \$1278 \$1232 GND GND sg13_lv_nmos L=0.13u W=0.3u AS=0.0525p
+ AD=0.331736842105p PS=0.65u PD=2.24315789474u rfmode=0
M$1058 \$1279 \$1233 GND GND sg13_lv_nmos L=0.13u W=0.3u AS=0.0525p
+ AD=0.331736842105p PS=0.65u PD=2.24315789474u rfmode=0
M$1059 \$1281 \$1234 GND GND sg13_lv_nmos L=0.13u W=0.3u AS=0.0525p
+ AD=0.331736842105p PS=0.65u PD=2.24315789474u rfmode=0
M$1060 \$1283 \$1235 GND GND sg13_lv_nmos L=0.13u W=0.3u AS=0.0525p
+ AD=0.331736842105p PS=0.65u PD=2.24315789474u rfmode=0
M$1061 \$1284 \$1236 GND GND sg13_lv_nmos L=0.13u W=0.3u AS=0.0525p
+ AD=0.331736842105p PS=0.65u PD=2.24315789474u rfmode=0
M$1062 \$1286 \$1237 GND GND sg13_lv_nmos L=0.13u W=0.3u AS=0.0525p
+ AD=0.331736842105p PS=0.65u PD=2.24315789474u rfmode=0
M$1063 \$1288 \$1238 GND GND sg13_lv_nmos L=0.13u W=0.3u AS=0.0525p
+ AD=0.331736842105p PS=0.65u PD=2.24315789474u rfmode=0
M$1064 \$1289 \$1239 GND GND sg13_lv_nmos L=0.13u W=0.3u AS=0.0525p
+ AD=0.331736842105p PS=0.65u PD=2.24315789474u rfmode=0
M$1065 GND \$1155 \$1213 GND sg13_lv_nmos L=0.13u W=0.3u AS=0.331736842105p
+ AD=0.0525p PS=2.24315789474u PD=0.65u rfmode=0
M$1066 GND \$1156 \$1214 GND sg13_lv_nmos L=0.13u W=0.3u AS=0.331736842105p
+ AD=0.0525p PS=2.24315789474u PD=0.65u rfmode=0
M$1067 GND \$1157 \$1216 GND sg13_lv_nmos L=0.13u W=0.3u AS=0.331736842105p
+ AD=0.0525p PS=2.24315789474u PD=0.65u rfmode=0
M$1068 GND \$1158 \$1217 GND sg13_lv_nmos L=0.13u W=0.3u AS=0.331736842105p
+ AD=0.0525p PS=2.24315789474u PD=0.65u rfmode=0
M$1069 GND \$1159 \$1215 GND sg13_lv_nmos L=0.13u W=0.3u AS=0.331736842105p
+ AD=0.0525p PS=2.24315789474u PD=0.65u rfmode=0
M$1070 GND \$1160 \$1212 GND sg13_lv_nmos L=0.13u W=0.3u AS=0.331736842105p
+ AD=0.0525p PS=2.24315789474u PD=0.65u rfmode=0
M$1071 GND \$1161 \$1211 GND sg13_lv_nmos L=0.13u W=0.3u AS=0.331736842105p
+ AD=0.0525p PS=2.24315789474u PD=0.65u rfmode=0
M$1072 GND \$1162 \$1208 GND sg13_lv_nmos L=0.13u W=0.3u AS=0.331736842105p
+ AD=0.0525p PS=2.24315789474u PD=0.65u rfmode=0
M$1073 GND \$1163 \$1205 GND sg13_lv_nmos L=0.13u W=0.3u AS=0.331736842105p
+ AD=0.0525p PS=2.24315789474u PD=0.65u rfmode=0
M$1074 GND \$1164 \$1203 GND sg13_lv_nmos L=0.13u W=0.3u AS=0.331736842105p
+ AD=0.0525p PS=2.24315789474u PD=0.65u rfmode=0
M$1075 GND \$1165 \$1200 GND sg13_lv_nmos L=0.13u W=0.3u AS=0.331736842105p
+ AD=0.0525p PS=2.24315789474u PD=0.65u rfmode=0
M$1076 GND \$1166 \$1198 GND sg13_lv_nmos L=0.13u W=0.3u AS=0.331736842105p
+ AD=0.0525p PS=2.24315789474u PD=0.65u rfmode=0
M$1077 GND \$1167 \$1195 GND sg13_lv_nmos L=0.13u W=0.3u AS=0.331736842105p
+ AD=0.0525p PS=2.24315789474u PD=0.65u rfmode=0
M$1078 GND \$1168 \$1192 GND sg13_lv_nmos L=0.13u W=0.3u AS=0.331736842105p
+ AD=0.0525p PS=2.24315789474u PD=0.65u rfmode=0
M$1079 GND \$1169 \$1190 GND sg13_lv_nmos L=0.13u W=0.3u AS=0.331736842105p
+ AD=0.0525p PS=2.24315789474u PD=0.65u rfmode=0
M$1080 GND \$1170 \$1187 GND sg13_lv_nmos L=0.13u W=0.3u AS=0.331736842105p
+ AD=0.0525p PS=2.24315789474u PD=0.65u rfmode=0
M$1081 GND \$1171 \$1184 GND sg13_lv_nmos L=0.13u W=0.3u AS=0.331736842105p
+ AD=0.0525p PS=2.24315789474u PD=0.65u rfmode=0
M$1082 GND \$1172 \$1182 GND sg13_lv_nmos L=0.13u W=0.3u AS=0.331736842105p
+ AD=0.0525p PS=2.24315789474u PD=0.65u rfmode=0
M$1083 GND \$1173 \$1180 GND sg13_lv_nmos L=0.13u W=0.3u AS=0.331736842105p
+ AD=0.0525p PS=2.24315789474u PD=0.65u rfmode=0
M$1084 \$1213 RWL[13] RBL[19] GND sg13_lv_nmos L=0.13u W=0.3u AS=0.0525p
+ AD=0.057p PS=0.65u PD=0.68u rfmode=0
M$1085 \$1214 RWL[13] RBL[20] GND sg13_lv_nmos L=0.13u W=0.3u AS=0.0525p
+ AD=0.057p PS=0.65u PD=0.68u rfmode=0
M$1086 \$1216 RWL[13] RBL[21] GND sg13_lv_nmos L=0.13u W=0.3u AS=0.0525p
+ AD=0.057p PS=0.65u PD=0.68u rfmode=0
M$1087 \$1217 RWL[13] RBL[22] GND sg13_lv_nmos L=0.13u W=0.3u AS=0.0525p
+ AD=0.057p PS=0.65u PD=0.68u rfmode=0
M$1088 \$1215 RWL[13] RBL[23] GND sg13_lv_nmos L=0.13u W=0.3u AS=0.0525p
+ AD=0.057p PS=0.65u PD=0.68u rfmode=0
M$1089 \$1212 RWL[13] RBL[24] GND sg13_lv_nmos L=0.13u W=0.3u AS=0.0525p
+ AD=0.057p PS=0.65u PD=0.68u rfmode=0
M$1090 \$1211 RWL[13] RBL[25] GND sg13_lv_nmos L=0.13u W=0.3u AS=0.0525p
+ AD=0.057p PS=0.65u PD=0.68u rfmode=0
M$1091 \$1208 RWL[13] RBL[26] GND sg13_lv_nmos L=0.13u W=0.3u AS=0.0525p
+ AD=0.057p PS=0.65u PD=0.68u rfmode=0
M$1092 \$1205 RWL[13] RBL[27] GND sg13_lv_nmos L=0.13u W=0.3u AS=0.0525p
+ AD=0.057p PS=0.65u PD=0.68u rfmode=0
M$1093 \$1203 RWL[13] RBL[28] GND sg13_lv_nmos L=0.13u W=0.3u AS=0.0525p
+ AD=0.057p PS=0.65u PD=0.68u rfmode=0
M$1094 \$1200 RWL[13] RBL[29] GND sg13_lv_nmos L=0.13u W=0.3u AS=0.0525p
+ AD=0.057p PS=0.65u PD=0.68u rfmode=0
M$1095 \$1198 RWL[13] RBL[30] GND sg13_lv_nmos L=0.13u W=0.3u AS=0.0525p
+ AD=0.057p PS=0.65u PD=0.68u rfmode=0
M$1096 \$1195 RWL[13] RBL[31] GND sg13_lv_nmos L=0.13u W=0.3u AS=0.0525p
+ AD=0.057p PS=0.65u PD=0.68u rfmode=0
M$1097 \$1192 RWL[13] RBL[32] GND sg13_lv_nmos L=0.13u W=0.3u AS=0.0525p
+ AD=0.057p PS=0.65u PD=0.68u rfmode=0
M$1098 \$1190 RWL[13] RBL[33] GND sg13_lv_nmos L=0.13u W=0.3u AS=0.0525p
+ AD=0.057p PS=0.65u PD=0.68u rfmode=0
M$1099 \$1187 RWL[13] RBL[34] GND sg13_lv_nmos L=0.13u W=0.3u AS=0.0525p
+ AD=0.057p PS=0.65u PD=0.68u rfmode=0
M$1100 \$1184 RWL[13] RBL[35] GND sg13_lv_nmos L=0.13u W=0.3u AS=0.0525p
+ AD=0.057p PS=0.65u PD=0.68u rfmode=0
M$1101 \$1182 RWL[13] RBL[36] GND sg13_lv_nmos L=0.13u W=0.3u AS=0.0525p
+ AD=0.057p PS=0.65u PD=0.68u rfmode=0
M$1102 \$1180 RWL[13] RBL[37] GND sg13_lv_nmos L=0.13u W=0.3u AS=0.0525p
+ AD=0.057p PS=0.65u PD=0.68u rfmode=0
M$1103 RBL[19] RWL[14] \$1292 GND sg13_lv_nmos L=0.13u W=0.3u AS=0.057p
+ AD=0.0525p PS=0.68u PD=0.65u rfmode=0
M$1104 RBL[20] RWL[14] \$1293 GND sg13_lv_nmos L=0.13u W=0.3u AS=0.057p
+ AD=0.0525p PS=0.68u PD=0.65u rfmode=0
M$1105 RBL[21] RWL[14] \$1295 GND sg13_lv_nmos L=0.13u W=0.3u AS=0.057p
+ AD=0.0525p PS=0.68u PD=0.65u rfmode=0
M$1106 RBL[22] RWL[14] \$1297 GND sg13_lv_nmos L=0.13u W=0.3u AS=0.057p
+ AD=0.0525p PS=0.68u PD=0.65u rfmode=0
M$1107 RBL[23] RWL[14] \$1298 GND sg13_lv_nmos L=0.13u W=0.3u AS=0.057p
+ AD=0.0525p PS=0.68u PD=0.65u rfmode=0
M$1108 RBL[24] RWL[14] \$1296 GND sg13_lv_nmos L=0.13u W=0.3u AS=0.057p
+ AD=0.0525p PS=0.68u PD=0.65u rfmode=0
M$1109 RBL[25] RWL[14] \$1294 GND sg13_lv_nmos L=0.13u W=0.3u AS=0.057p
+ AD=0.0525p PS=0.68u PD=0.65u rfmode=0
M$1110 RBL[26] RWL[14] \$1291 GND sg13_lv_nmos L=0.13u W=0.3u AS=0.057p
+ AD=0.0525p PS=0.68u PD=0.65u rfmode=0
M$1111 RBL[27] RWL[14] \$1290 GND sg13_lv_nmos L=0.13u W=0.3u AS=0.057p
+ AD=0.0525p PS=0.68u PD=0.65u rfmode=0
M$1112 RBL[28] RWL[14] \$1287 GND sg13_lv_nmos L=0.13u W=0.3u AS=0.057p
+ AD=0.0525p PS=0.68u PD=0.65u rfmode=0
M$1113 RBL[29] RWL[14] \$1285 GND sg13_lv_nmos L=0.13u W=0.3u AS=0.057p
+ AD=0.0525p PS=0.68u PD=0.65u rfmode=0
M$1114 RBL[30] RWL[14] \$1282 GND sg13_lv_nmos L=0.13u W=0.3u AS=0.057p
+ AD=0.0525p PS=0.68u PD=0.65u rfmode=0
M$1115 RBL[31] RWL[14] \$1280 GND sg13_lv_nmos L=0.13u W=0.3u AS=0.057p
+ AD=0.0525p PS=0.68u PD=0.65u rfmode=0
M$1116 RBL[32] RWL[14] \$1276 GND sg13_lv_nmos L=0.13u W=0.3u AS=0.057p
+ AD=0.0525p PS=0.68u PD=0.65u rfmode=0
M$1117 RBL[33] RWL[14] \$1274 GND sg13_lv_nmos L=0.13u W=0.3u AS=0.057p
+ AD=0.0525p PS=0.68u PD=0.65u rfmode=0
M$1118 RBL[34] RWL[14] \$1272 GND sg13_lv_nmos L=0.13u W=0.3u AS=0.057p
+ AD=0.0525p PS=0.68u PD=0.65u rfmode=0
M$1119 RBL[35] RWL[14] \$1269 GND sg13_lv_nmos L=0.13u W=0.3u AS=0.057p
+ AD=0.0525p PS=0.68u PD=0.65u rfmode=0
M$1120 RBL[36] RWL[14] \$1267 GND sg13_lv_nmos L=0.13u W=0.3u AS=0.057p
+ AD=0.0525p PS=0.68u PD=0.65u rfmode=0
M$1121 RBL[37] RWL[14] \$1264 GND sg13_lv_nmos L=0.13u W=0.3u AS=0.057p
+ AD=0.0525p PS=0.68u PD=0.65u rfmode=0
M$1122 \$1292 \$1240 GND GND sg13_lv_nmos L=0.13u W=0.3u AS=0.0525p
+ AD=0.331736842105p PS=0.65u PD=2.24315789474u rfmode=0
M$1123 \$1293 \$1241 GND GND sg13_lv_nmos L=0.13u W=0.3u AS=0.0525p
+ AD=0.331736842105p PS=0.65u PD=2.24315789474u rfmode=0
M$1124 \$1295 \$1242 GND GND sg13_lv_nmos L=0.13u W=0.3u AS=0.0525p
+ AD=0.331736842105p PS=0.65u PD=2.24315789474u rfmode=0
M$1125 \$1297 \$1243 GND GND sg13_lv_nmos L=0.13u W=0.3u AS=0.0525p
+ AD=0.331736842105p PS=0.65u PD=2.24315789474u rfmode=0
M$1126 \$1298 \$1244 GND GND sg13_lv_nmos L=0.13u W=0.3u AS=0.0525p
+ AD=0.331736842105p PS=0.65u PD=2.24315789474u rfmode=0
M$1127 \$1296 \$1245 GND GND sg13_lv_nmos L=0.13u W=0.3u AS=0.0525p
+ AD=0.331736842105p PS=0.65u PD=2.24315789474u rfmode=0
M$1128 \$1294 \$1246 GND GND sg13_lv_nmos L=0.13u W=0.3u AS=0.0525p
+ AD=0.331736842105p PS=0.65u PD=2.24315789474u rfmode=0
M$1129 \$1291 \$1247 GND GND sg13_lv_nmos L=0.13u W=0.3u AS=0.0525p
+ AD=0.331736842105p PS=0.65u PD=2.24315789474u rfmode=0
M$1130 \$1290 \$1248 GND GND sg13_lv_nmos L=0.13u W=0.3u AS=0.0525p
+ AD=0.331736842105p PS=0.65u PD=2.24315789474u rfmode=0
M$1131 \$1287 \$1249 GND GND sg13_lv_nmos L=0.13u W=0.3u AS=0.0525p
+ AD=0.331736842105p PS=0.65u PD=2.24315789474u rfmode=0
M$1132 \$1285 \$1250 GND GND sg13_lv_nmos L=0.13u W=0.3u AS=0.0525p
+ AD=0.331736842105p PS=0.65u PD=2.24315789474u rfmode=0
M$1133 \$1282 \$1251 GND GND sg13_lv_nmos L=0.13u W=0.3u AS=0.0525p
+ AD=0.331736842105p PS=0.65u PD=2.24315789474u rfmode=0
M$1134 \$1280 \$1252 GND GND sg13_lv_nmos L=0.13u W=0.3u AS=0.0525p
+ AD=0.331736842105p PS=0.65u PD=2.24315789474u rfmode=0
M$1135 \$1276 \$1253 GND GND sg13_lv_nmos L=0.13u W=0.3u AS=0.0525p
+ AD=0.331736842105p PS=0.65u PD=2.24315789474u rfmode=0
M$1136 \$1274 \$1254 GND GND sg13_lv_nmos L=0.13u W=0.3u AS=0.0525p
+ AD=0.331736842105p PS=0.65u PD=2.24315789474u rfmode=0
M$1137 \$1272 \$1255 GND GND sg13_lv_nmos L=0.13u W=0.3u AS=0.0525p
+ AD=0.331736842105p PS=0.65u PD=2.24315789474u rfmode=0
M$1138 \$1269 \$1256 GND GND sg13_lv_nmos L=0.13u W=0.3u AS=0.0525p
+ AD=0.331736842105p PS=0.65u PD=2.24315789474u rfmode=0
M$1139 \$1267 \$1257 GND GND sg13_lv_nmos L=0.13u W=0.3u AS=0.0525p
+ AD=0.331736842105p PS=0.65u PD=2.24315789474u rfmode=0
M$1140 \$1264 \$1258 GND GND sg13_lv_nmos L=0.13u W=0.3u AS=0.0525p
+ AD=0.331736842105p PS=0.65u PD=2.24315789474u rfmode=0
M$1141 GND \$1299 \$1344 GND sg13_lv_nmos L=0.13u W=0.3u AS=0.331736842105p
+ AD=0.0525p PS=2.24315789474u PD=0.65u rfmode=0
M$1142 GND \$1300 \$1346 GND sg13_lv_nmos L=0.13u W=0.3u AS=0.331736842105p
+ AD=0.0525p PS=2.24315789474u PD=0.65u rfmode=0
M$1143 GND \$1301 \$1348 GND sg13_lv_nmos L=0.13u W=0.3u AS=0.331736842105p
+ AD=0.0525p PS=2.24315789474u PD=0.65u rfmode=0
M$1144 GND \$1302 \$1349 GND sg13_lv_nmos L=0.13u W=0.3u AS=0.331736842105p
+ AD=0.0525p PS=2.24315789474u PD=0.65u rfmode=0
M$1145 GND \$1303 \$1351 GND sg13_lv_nmos L=0.13u W=0.3u AS=0.331736842105p
+ AD=0.0525p PS=2.24315789474u PD=0.65u rfmode=0
M$1146 GND \$1304 \$1352 GND sg13_lv_nmos L=0.13u W=0.3u AS=0.331736842105p
+ AD=0.0525p PS=2.24315789474u PD=0.65u rfmode=0
M$1147 GND \$1305 \$1354 GND sg13_lv_nmos L=0.13u W=0.3u AS=0.331736842105p
+ AD=0.0525p PS=2.24315789474u PD=0.65u rfmode=0
M$1148 GND \$1306 \$1356 GND sg13_lv_nmos L=0.13u W=0.3u AS=0.331736842105p
+ AD=0.0525p PS=2.24315789474u PD=0.65u rfmode=0
M$1149 GND \$1307 \$1357 GND sg13_lv_nmos L=0.13u W=0.3u AS=0.331736842105p
+ AD=0.0525p PS=2.24315789474u PD=0.65u rfmode=0
M$1150 GND \$1308 \$1359 GND sg13_lv_nmos L=0.13u W=0.3u AS=0.331736842105p
+ AD=0.0525p PS=2.24315789474u PD=0.65u rfmode=0
M$1151 GND \$1309 \$1361 GND sg13_lv_nmos L=0.13u W=0.3u AS=0.331736842105p
+ AD=0.0525p PS=2.24315789474u PD=0.65u rfmode=0
M$1152 GND \$1310 \$1362 GND sg13_lv_nmos L=0.13u W=0.3u AS=0.331736842105p
+ AD=0.0525p PS=2.24315789474u PD=0.65u rfmode=0
M$1153 GND \$1311 \$1364 GND sg13_lv_nmos L=0.13u W=0.3u AS=0.331736842105p
+ AD=0.0525p PS=2.24315789474u PD=0.65u rfmode=0
M$1154 GND \$1312 \$1365 GND sg13_lv_nmos L=0.13u W=0.3u AS=0.331736842105p
+ AD=0.0525p PS=2.24315789474u PD=0.65u rfmode=0
M$1155 GND \$1313 \$1367 GND sg13_lv_nmos L=0.13u W=0.3u AS=0.331736842105p
+ AD=0.0525p PS=2.24315789474u PD=0.65u rfmode=0
M$1156 GND \$1314 \$1368 GND sg13_lv_nmos L=0.13u W=0.3u AS=0.331736842105p
+ AD=0.0525p PS=2.24315789474u PD=0.65u rfmode=0
M$1157 GND \$1315 \$1370 GND sg13_lv_nmos L=0.13u W=0.3u AS=0.331736842105p
+ AD=0.0525p PS=2.24315789474u PD=0.65u rfmode=0
M$1158 GND \$1316 \$1372 GND sg13_lv_nmos L=0.13u W=0.3u AS=0.331736842105p
+ AD=0.0525p PS=2.24315789474u PD=0.65u rfmode=0
M$1159 GND \$1317 \$1373 GND sg13_lv_nmos L=0.13u W=0.3u AS=0.331736842105p
+ AD=0.0525p PS=2.24315789474u PD=0.65u rfmode=0
M$1160 \$1344 RWL[15] RBL[0] GND sg13_lv_nmos L=0.13u W=0.3u AS=0.0525p
+ AD=0.057p PS=0.65u PD=0.68u rfmode=0
M$1161 \$1346 RWL[15] RBL[1] GND sg13_lv_nmos L=0.13u W=0.3u AS=0.0525p
+ AD=0.057p PS=0.65u PD=0.68u rfmode=0
M$1162 \$1348 RWL[15] RBL[2] GND sg13_lv_nmos L=0.13u W=0.3u AS=0.0525p
+ AD=0.057p PS=0.65u PD=0.68u rfmode=0
M$1163 \$1349 RWL[15] RBL[3] GND sg13_lv_nmos L=0.13u W=0.3u AS=0.0525p
+ AD=0.057p PS=0.65u PD=0.68u rfmode=0
M$1164 \$1351 RWL[15] RBL[4] GND sg13_lv_nmos L=0.13u W=0.3u AS=0.0525p
+ AD=0.057p PS=0.65u PD=0.68u rfmode=0
M$1165 \$1352 RWL[15] RBL[5] GND sg13_lv_nmos L=0.13u W=0.3u AS=0.0525p
+ AD=0.057p PS=0.65u PD=0.68u rfmode=0
M$1166 \$1354 RWL[15] RBL[6] GND sg13_lv_nmos L=0.13u W=0.3u AS=0.0525p
+ AD=0.057p PS=0.65u PD=0.68u rfmode=0
M$1167 \$1356 RWL[15] RBL[7] GND sg13_lv_nmos L=0.13u W=0.3u AS=0.0525p
+ AD=0.057p PS=0.65u PD=0.68u rfmode=0
M$1168 \$1357 RWL[15] RBL[8] GND sg13_lv_nmos L=0.13u W=0.3u AS=0.0525p
+ AD=0.057p PS=0.65u PD=0.68u rfmode=0
M$1169 \$1359 RWL[15] RBL[9] GND sg13_lv_nmos L=0.13u W=0.3u AS=0.0525p
+ AD=0.057p PS=0.65u PD=0.68u rfmode=0
M$1170 \$1361 RWL[15] RBL[10] GND sg13_lv_nmos L=0.13u W=0.3u AS=0.0525p
+ AD=0.057p PS=0.65u PD=0.68u rfmode=0
M$1171 \$1362 RWL[15] RBL[11] GND sg13_lv_nmos L=0.13u W=0.3u AS=0.0525p
+ AD=0.057p PS=0.65u PD=0.68u rfmode=0
M$1172 \$1364 RWL[15] RBL[12] GND sg13_lv_nmos L=0.13u W=0.3u AS=0.0525p
+ AD=0.057p PS=0.65u PD=0.68u rfmode=0
M$1173 \$1365 RWL[15] RBL[13] GND sg13_lv_nmos L=0.13u W=0.3u AS=0.0525p
+ AD=0.057p PS=0.65u PD=0.68u rfmode=0
M$1174 \$1367 RWL[15] RBL[14] GND sg13_lv_nmos L=0.13u W=0.3u AS=0.0525p
+ AD=0.057p PS=0.65u PD=0.68u rfmode=0
M$1175 \$1368 RWL[15] RBL[15] GND sg13_lv_nmos L=0.13u W=0.3u AS=0.0525p
+ AD=0.057p PS=0.65u PD=0.68u rfmode=0
M$1176 \$1370 RWL[15] RBL[16] GND sg13_lv_nmos L=0.13u W=0.3u AS=0.0525p
+ AD=0.057p PS=0.65u PD=0.68u rfmode=0
M$1177 \$1372 RWL[15] RBL[17] GND sg13_lv_nmos L=0.13u W=0.3u AS=0.0525p
+ AD=0.057p PS=0.65u PD=0.68u rfmode=0
M$1178 \$1373 RWL[15] RBL[18] GND sg13_lv_nmos L=0.13u W=0.3u AS=0.0525p
+ AD=0.057p PS=0.65u PD=0.68u rfmode=0
M$1179 RBL[0] RWL[16] \$1424 GND sg13_lv_nmos L=0.13u W=0.3u AS=0.057p
+ AD=0.0525p PS=0.68u PD=0.65u rfmode=0
M$1180 RBL[1] RWL[16] \$1425 GND sg13_lv_nmos L=0.13u W=0.3u AS=0.057p
+ AD=0.0525p PS=0.68u PD=0.65u rfmode=0
M$1181 RBL[2] RWL[16] \$1426 GND sg13_lv_nmos L=0.13u W=0.3u AS=0.057p
+ AD=0.0525p PS=0.68u PD=0.65u rfmode=0
M$1182 RBL[3] RWL[16] \$1428 GND sg13_lv_nmos L=0.13u W=0.3u AS=0.057p
+ AD=0.0525p PS=0.68u PD=0.65u rfmode=0
M$1183 RBL[4] RWL[16] \$1429 GND sg13_lv_nmos L=0.13u W=0.3u AS=0.057p
+ AD=0.0525p PS=0.68u PD=0.65u rfmode=0
M$1184 RBL[5] RWL[16] \$1431 GND sg13_lv_nmos L=0.13u W=0.3u AS=0.057p
+ AD=0.0525p PS=0.68u PD=0.65u rfmode=0
M$1185 RBL[6] RWL[16] \$1433 GND sg13_lv_nmos L=0.13u W=0.3u AS=0.057p
+ AD=0.0525p PS=0.68u PD=0.65u rfmode=0
M$1186 RBL[7] RWL[16] \$1434 GND sg13_lv_nmos L=0.13u W=0.3u AS=0.057p
+ AD=0.0525p PS=0.68u PD=0.65u rfmode=0
M$1187 RBL[8] RWL[16] \$1436 GND sg13_lv_nmos L=0.13u W=0.3u AS=0.057p
+ AD=0.0525p PS=0.68u PD=0.65u rfmode=0
M$1188 RBL[9] RWL[16] \$1437 GND sg13_lv_nmos L=0.13u W=0.3u AS=0.057p
+ AD=0.0525p PS=0.68u PD=0.65u rfmode=0
M$1189 RBL[10] RWL[16] \$1440 GND sg13_lv_nmos L=0.13u W=0.3u AS=0.057p
+ AD=0.0525p PS=0.68u PD=0.65u rfmode=0
M$1190 RBL[11] RWL[16] \$1441 GND sg13_lv_nmos L=0.13u W=0.3u AS=0.057p
+ AD=0.0525p PS=0.68u PD=0.65u rfmode=0
M$1191 RBL[12] RWL[16] \$1443 GND sg13_lv_nmos L=0.13u W=0.3u AS=0.057p
+ AD=0.0525p PS=0.68u PD=0.65u rfmode=0
M$1192 RBL[13] RWL[16] \$1444 GND sg13_lv_nmos L=0.13u W=0.3u AS=0.057p
+ AD=0.0525p PS=0.68u PD=0.65u rfmode=0
M$1193 RBL[14] RWL[16] \$1446 GND sg13_lv_nmos L=0.13u W=0.3u AS=0.057p
+ AD=0.0525p PS=0.68u PD=0.65u rfmode=0
M$1194 RBL[15] RWL[16] \$1448 GND sg13_lv_nmos L=0.13u W=0.3u AS=0.057p
+ AD=0.0525p PS=0.68u PD=0.65u rfmode=0
M$1195 RBL[16] RWL[16] \$1449 GND sg13_lv_nmos L=0.13u W=0.3u AS=0.057p
+ AD=0.0525p PS=0.68u PD=0.65u rfmode=0
M$1196 RBL[17] RWL[16] \$1451 GND sg13_lv_nmos L=0.13u W=0.3u AS=0.057p
+ AD=0.0525p PS=0.68u PD=0.65u rfmode=0
M$1197 RBL[18] RWL[16] \$1452 GND sg13_lv_nmos L=0.13u W=0.3u AS=0.057p
+ AD=0.0525p PS=0.68u PD=0.65u rfmode=0
M$1198 \$1424 \$1384 GND GND sg13_lv_nmos L=0.13u W=0.3u AS=0.0525p
+ AD=0.331736842105p PS=0.65u PD=2.24315789474u rfmode=0
M$1199 \$1425 \$1385 GND GND sg13_lv_nmos L=0.13u W=0.3u AS=0.0525p
+ AD=0.331736842105p PS=0.65u PD=2.24315789474u rfmode=0
M$1200 \$1426 \$1386 GND GND sg13_lv_nmos L=0.13u W=0.3u AS=0.0525p
+ AD=0.331736842105p PS=0.65u PD=2.24315789474u rfmode=0
M$1201 \$1428 \$1387 GND GND sg13_lv_nmos L=0.13u W=0.3u AS=0.0525p
+ AD=0.331736842105p PS=0.65u PD=2.24315789474u rfmode=0
M$1202 \$1429 \$1388 GND GND sg13_lv_nmos L=0.13u W=0.3u AS=0.0525p
+ AD=0.331736842105p PS=0.65u PD=2.24315789474u rfmode=0
M$1203 \$1431 \$1389 GND GND sg13_lv_nmos L=0.13u W=0.3u AS=0.0525p
+ AD=0.331736842105p PS=0.65u PD=2.24315789474u rfmode=0
M$1204 \$1433 \$1390 GND GND sg13_lv_nmos L=0.13u W=0.3u AS=0.0525p
+ AD=0.331736842105p PS=0.65u PD=2.24315789474u rfmode=0
M$1205 \$1434 \$1391 GND GND sg13_lv_nmos L=0.13u W=0.3u AS=0.0525p
+ AD=0.331736842105p PS=0.65u PD=2.24315789474u rfmode=0
M$1206 \$1436 \$1392 GND GND sg13_lv_nmos L=0.13u W=0.3u AS=0.0525p
+ AD=0.331736842105p PS=0.65u PD=2.24315789474u rfmode=0
M$1207 \$1437 \$1393 GND GND sg13_lv_nmos L=0.13u W=0.3u AS=0.0525p
+ AD=0.331736842105p PS=0.65u PD=2.24315789474u rfmode=0
M$1208 \$1440 \$1394 GND GND sg13_lv_nmos L=0.13u W=0.3u AS=0.0525p
+ AD=0.331736842105p PS=0.65u PD=2.24315789474u rfmode=0
M$1209 \$1441 \$1395 GND GND sg13_lv_nmos L=0.13u W=0.3u AS=0.0525p
+ AD=0.331736842105p PS=0.65u PD=2.24315789474u rfmode=0
M$1210 \$1443 \$1396 GND GND sg13_lv_nmos L=0.13u W=0.3u AS=0.0525p
+ AD=0.331736842105p PS=0.65u PD=2.24315789474u rfmode=0
M$1211 \$1444 \$1397 GND GND sg13_lv_nmos L=0.13u W=0.3u AS=0.0525p
+ AD=0.331736842105p PS=0.65u PD=2.24315789474u rfmode=0
M$1212 \$1446 \$1398 GND GND sg13_lv_nmos L=0.13u W=0.3u AS=0.0525p
+ AD=0.331736842105p PS=0.65u PD=2.24315789474u rfmode=0
M$1213 \$1448 \$1399 GND GND sg13_lv_nmos L=0.13u W=0.3u AS=0.0525p
+ AD=0.331736842105p PS=0.65u PD=2.24315789474u rfmode=0
M$1214 \$1449 \$1400 GND GND sg13_lv_nmos L=0.13u W=0.3u AS=0.0525p
+ AD=0.331736842105p PS=0.65u PD=2.24315789474u rfmode=0
M$1215 \$1451 \$1401 GND GND sg13_lv_nmos L=0.13u W=0.3u AS=0.0525p
+ AD=0.331736842105p PS=0.65u PD=2.24315789474u rfmode=0
M$1216 \$1452 \$1402 GND GND sg13_lv_nmos L=0.13u W=0.3u AS=0.0525p
+ AD=0.331736842105p PS=0.65u PD=2.24315789474u rfmode=0
M$1217 GND \$1318 \$1375 GND sg13_lv_nmos L=0.13u W=0.3u AS=0.331736842105p
+ AD=0.0525p PS=2.24315789474u PD=0.65u rfmode=0
M$1218 GND \$1319 \$1377 GND sg13_lv_nmos L=0.13u W=0.3u AS=0.331736842105p
+ AD=0.0525p PS=2.24315789474u PD=0.65u rfmode=0
M$1219 GND \$1320 \$1379 GND sg13_lv_nmos L=0.13u W=0.3u AS=0.331736842105p
+ AD=0.0525p PS=2.24315789474u PD=0.65u rfmode=0
M$1220 GND \$1321 \$1380 GND sg13_lv_nmos L=0.13u W=0.3u AS=0.331736842105p
+ AD=0.0525p PS=2.24315789474u PD=0.65u rfmode=0
M$1221 GND \$1322 \$1378 GND sg13_lv_nmos L=0.13u W=0.3u AS=0.331736842105p
+ AD=0.0525p PS=2.24315789474u PD=0.65u rfmode=0
M$1222 GND \$1323 \$1376 GND sg13_lv_nmos L=0.13u W=0.3u AS=0.331736842105p
+ AD=0.0525p PS=2.24315789474u PD=0.65u rfmode=0
M$1223 GND \$1324 \$1374 GND sg13_lv_nmos L=0.13u W=0.3u AS=0.331736842105p
+ AD=0.0525p PS=2.24315789474u PD=0.65u rfmode=0
M$1224 GND \$1325 \$1371 GND sg13_lv_nmos L=0.13u W=0.3u AS=0.331736842105p
+ AD=0.0525p PS=2.24315789474u PD=0.65u rfmode=0
M$1225 GND \$1326 \$1369 GND sg13_lv_nmos L=0.13u W=0.3u AS=0.331736842105p
+ AD=0.0525p PS=2.24315789474u PD=0.65u rfmode=0
M$1226 GND \$1327 \$1366 GND sg13_lv_nmos L=0.13u W=0.3u AS=0.331736842105p
+ AD=0.0525p PS=2.24315789474u PD=0.65u rfmode=0
M$1227 GND \$1328 \$1363 GND sg13_lv_nmos L=0.13u W=0.3u AS=0.331736842105p
+ AD=0.0525p PS=2.24315789474u PD=0.65u rfmode=0
M$1228 GND \$1329 \$1360 GND sg13_lv_nmos L=0.13u W=0.3u AS=0.331736842105p
+ AD=0.0525p PS=2.24315789474u PD=0.65u rfmode=0
M$1229 GND \$1330 \$1358 GND sg13_lv_nmos L=0.13u W=0.3u AS=0.331736842105p
+ AD=0.0525p PS=2.24315789474u PD=0.65u rfmode=0
M$1230 GND \$1331 \$1355 GND sg13_lv_nmos L=0.13u W=0.3u AS=0.331736842105p
+ AD=0.0525p PS=2.24315789474u PD=0.65u rfmode=0
M$1231 GND \$1332 \$1353 GND sg13_lv_nmos L=0.13u W=0.3u AS=0.331736842105p
+ AD=0.0525p PS=2.24315789474u PD=0.65u rfmode=0
M$1232 GND \$1333 \$1350 GND sg13_lv_nmos L=0.13u W=0.3u AS=0.331736842105p
+ AD=0.0525p PS=2.24315789474u PD=0.65u rfmode=0
M$1233 GND \$1334 \$1347 GND sg13_lv_nmos L=0.13u W=0.3u AS=0.331736842105p
+ AD=0.0525p PS=2.24315789474u PD=0.65u rfmode=0
M$1234 GND \$1335 \$1345 GND sg13_lv_nmos L=0.13u W=0.3u AS=0.331736842105p
+ AD=0.0525p PS=2.24315789474u PD=0.65u rfmode=0
M$1235 GND \$1336 \$1343 GND sg13_lv_nmos L=0.13u W=0.3u AS=0.331736842105p
+ AD=0.0525p PS=2.24315789474u PD=0.65u rfmode=0
M$1236 \$1375 RWL[15] RBL[19] GND sg13_lv_nmos L=0.13u W=0.3u AS=0.0525p
+ AD=0.057p PS=0.65u PD=0.68u rfmode=0
M$1237 \$1377 RWL[15] RBL[20] GND sg13_lv_nmos L=0.13u W=0.3u AS=0.0525p
+ AD=0.057p PS=0.65u PD=0.68u rfmode=0
M$1238 \$1379 RWL[15] RBL[21] GND sg13_lv_nmos L=0.13u W=0.3u AS=0.0525p
+ AD=0.057p PS=0.65u PD=0.68u rfmode=0
M$1239 \$1380 RWL[15] RBL[22] GND sg13_lv_nmos L=0.13u W=0.3u AS=0.0525p
+ AD=0.057p PS=0.65u PD=0.68u rfmode=0
M$1240 \$1378 RWL[15] RBL[23] GND sg13_lv_nmos L=0.13u W=0.3u AS=0.0525p
+ AD=0.057p PS=0.65u PD=0.68u rfmode=0
M$1241 \$1376 RWL[15] RBL[24] GND sg13_lv_nmos L=0.13u W=0.3u AS=0.0525p
+ AD=0.057p PS=0.65u PD=0.68u rfmode=0
M$1242 \$1374 RWL[15] RBL[25] GND sg13_lv_nmos L=0.13u W=0.3u AS=0.0525p
+ AD=0.057p PS=0.65u PD=0.68u rfmode=0
M$1243 \$1371 RWL[15] RBL[26] GND sg13_lv_nmos L=0.13u W=0.3u AS=0.0525p
+ AD=0.057p PS=0.65u PD=0.68u rfmode=0
M$1244 \$1369 RWL[15] RBL[27] GND sg13_lv_nmos L=0.13u W=0.3u AS=0.0525p
+ AD=0.057p PS=0.65u PD=0.68u rfmode=0
M$1245 \$1366 RWL[15] RBL[28] GND sg13_lv_nmos L=0.13u W=0.3u AS=0.0525p
+ AD=0.057p PS=0.65u PD=0.68u rfmode=0
M$1246 \$1363 RWL[15] RBL[29] GND sg13_lv_nmos L=0.13u W=0.3u AS=0.0525p
+ AD=0.057p PS=0.65u PD=0.68u rfmode=0
M$1247 \$1360 RWL[15] RBL[30] GND sg13_lv_nmos L=0.13u W=0.3u AS=0.0525p
+ AD=0.057p PS=0.65u PD=0.68u rfmode=0
M$1248 \$1358 RWL[15] RBL[31] GND sg13_lv_nmos L=0.13u W=0.3u AS=0.0525p
+ AD=0.057p PS=0.65u PD=0.68u rfmode=0
M$1249 \$1355 RWL[15] RBL[32] GND sg13_lv_nmos L=0.13u W=0.3u AS=0.0525p
+ AD=0.057p PS=0.65u PD=0.68u rfmode=0
M$1250 \$1353 RWL[15] RBL[33] GND sg13_lv_nmos L=0.13u W=0.3u AS=0.0525p
+ AD=0.057p PS=0.65u PD=0.68u rfmode=0
M$1251 \$1350 RWL[15] RBL[34] GND sg13_lv_nmos L=0.13u W=0.3u AS=0.0525p
+ AD=0.057p PS=0.65u PD=0.68u rfmode=0
M$1252 \$1347 RWL[15] RBL[35] GND sg13_lv_nmos L=0.13u W=0.3u AS=0.0525p
+ AD=0.057p PS=0.65u PD=0.68u rfmode=0
M$1253 \$1345 RWL[15] RBL[36] GND sg13_lv_nmos L=0.13u W=0.3u AS=0.0525p
+ AD=0.057p PS=0.65u PD=0.68u rfmode=0
M$1254 \$1343 RWL[15] RBL[37] GND sg13_lv_nmos L=0.13u W=0.3u AS=0.0525p
+ AD=0.057p PS=0.65u PD=0.68u rfmode=0
M$1255 RBL[19] RWL[16] \$1455 GND sg13_lv_nmos L=0.13u W=0.3u AS=0.057p
+ AD=0.0525p PS=0.68u PD=0.65u rfmode=0
M$1256 RBL[20] RWL[16] \$1456 GND sg13_lv_nmos L=0.13u W=0.3u AS=0.057p
+ AD=0.0525p PS=0.68u PD=0.65u rfmode=0
M$1257 RBL[21] RWL[16] \$1458 GND sg13_lv_nmos L=0.13u W=0.3u AS=0.057p
+ AD=0.0525p PS=0.68u PD=0.65u rfmode=0
M$1258 RBL[22] RWL[16] \$1459 GND sg13_lv_nmos L=0.13u W=0.3u AS=0.057p
+ AD=0.0525p PS=0.68u PD=0.65u rfmode=0
M$1259 RBL[23] RWL[16] \$1461 GND sg13_lv_nmos L=0.13u W=0.3u AS=0.057p
+ AD=0.0525p PS=0.68u PD=0.65u rfmode=0
M$1260 RBL[24] RWL[16] \$1460 GND sg13_lv_nmos L=0.13u W=0.3u AS=0.057p
+ AD=0.0525p PS=0.68u PD=0.65u rfmode=0
M$1261 RBL[25] RWL[16] \$1457 GND sg13_lv_nmos L=0.13u W=0.3u AS=0.057p
+ AD=0.0525p PS=0.68u PD=0.65u rfmode=0
M$1262 RBL[26] RWL[16] \$1454 GND sg13_lv_nmos L=0.13u W=0.3u AS=0.057p
+ AD=0.0525p PS=0.68u PD=0.65u rfmode=0
M$1263 RBL[27] RWL[16] \$1453 GND sg13_lv_nmos L=0.13u W=0.3u AS=0.057p
+ AD=0.0525p PS=0.68u PD=0.65u rfmode=0
M$1264 RBL[28] RWL[16] \$1450 GND sg13_lv_nmos L=0.13u W=0.3u AS=0.057p
+ AD=0.0525p PS=0.68u PD=0.65u rfmode=0
M$1265 RBL[29] RWL[16] \$1447 GND sg13_lv_nmos L=0.13u W=0.3u AS=0.057p
+ AD=0.0525p PS=0.68u PD=0.65u rfmode=0
M$1266 RBL[30] RWL[16] \$1445 GND sg13_lv_nmos L=0.13u W=0.3u AS=0.057p
+ AD=0.0525p PS=0.68u PD=0.65u rfmode=0
M$1267 RBL[31] RWL[16] \$1442 GND sg13_lv_nmos L=0.13u W=0.3u AS=0.057p
+ AD=0.0525p PS=0.68u PD=0.65u rfmode=0
M$1268 RBL[32] RWL[16] \$1439 GND sg13_lv_nmos L=0.13u W=0.3u AS=0.057p
+ AD=0.0525p PS=0.68u PD=0.65u rfmode=0
M$1269 RBL[33] RWL[16] \$1438 GND sg13_lv_nmos L=0.13u W=0.3u AS=0.057p
+ AD=0.0525p PS=0.68u PD=0.65u rfmode=0
M$1270 RBL[34] RWL[16] \$1435 GND sg13_lv_nmos L=0.13u W=0.3u AS=0.057p
+ AD=0.0525p PS=0.68u PD=0.65u rfmode=0
M$1271 RBL[35] RWL[16] \$1432 GND sg13_lv_nmos L=0.13u W=0.3u AS=0.057p
+ AD=0.0525p PS=0.68u PD=0.65u rfmode=0
M$1272 RBL[36] RWL[16] \$1430 GND sg13_lv_nmos L=0.13u W=0.3u AS=0.057p
+ AD=0.0525p PS=0.68u PD=0.65u rfmode=0
M$1273 RBL[37] RWL[16] \$1427 GND sg13_lv_nmos L=0.13u W=0.3u AS=0.057p
+ AD=0.0525p PS=0.68u PD=0.65u rfmode=0
M$1274 \$1455 \$1403 GND GND sg13_lv_nmos L=0.13u W=0.3u AS=0.0525p
+ AD=0.331736842105p PS=0.65u PD=2.24315789474u rfmode=0
M$1275 \$1456 \$1404 GND GND sg13_lv_nmos L=0.13u W=0.3u AS=0.0525p
+ AD=0.331736842105p PS=0.65u PD=2.24315789474u rfmode=0
M$1276 \$1458 \$1405 GND GND sg13_lv_nmos L=0.13u W=0.3u AS=0.0525p
+ AD=0.331736842105p PS=0.65u PD=2.24315789474u rfmode=0
M$1277 \$1459 \$1406 GND GND sg13_lv_nmos L=0.13u W=0.3u AS=0.0525p
+ AD=0.331736842105p PS=0.65u PD=2.24315789474u rfmode=0
M$1278 \$1461 \$1407 GND GND sg13_lv_nmos L=0.13u W=0.3u AS=0.0525p
+ AD=0.331736842105p PS=0.65u PD=2.24315789474u rfmode=0
M$1279 \$1460 \$1408 GND GND sg13_lv_nmos L=0.13u W=0.3u AS=0.0525p
+ AD=0.331736842105p PS=0.65u PD=2.24315789474u rfmode=0
M$1280 \$1457 \$1409 GND GND sg13_lv_nmos L=0.13u W=0.3u AS=0.0525p
+ AD=0.331736842105p PS=0.65u PD=2.24315789474u rfmode=0
M$1281 \$1454 \$1410 GND GND sg13_lv_nmos L=0.13u W=0.3u AS=0.0525p
+ AD=0.331736842105p PS=0.65u PD=2.24315789474u rfmode=0
M$1282 \$1453 \$1411 GND GND sg13_lv_nmos L=0.13u W=0.3u AS=0.0525p
+ AD=0.331736842105p PS=0.65u PD=2.24315789474u rfmode=0
M$1283 \$1450 \$1412 GND GND sg13_lv_nmos L=0.13u W=0.3u AS=0.0525p
+ AD=0.331736842105p PS=0.65u PD=2.24315789474u rfmode=0
M$1284 \$1447 \$1413 GND GND sg13_lv_nmos L=0.13u W=0.3u AS=0.0525p
+ AD=0.331736842105p PS=0.65u PD=2.24315789474u rfmode=0
M$1285 \$1445 \$1414 GND GND sg13_lv_nmos L=0.13u W=0.3u AS=0.0525p
+ AD=0.331736842105p PS=0.65u PD=2.24315789474u rfmode=0
M$1286 \$1442 \$1415 GND GND sg13_lv_nmos L=0.13u W=0.3u AS=0.0525p
+ AD=0.331736842105p PS=0.65u PD=2.24315789474u rfmode=0
M$1287 \$1439 \$1416 GND GND sg13_lv_nmos L=0.13u W=0.3u AS=0.0525p
+ AD=0.331736842105p PS=0.65u PD=2.24315789474u rfmode=0
M$1288 \$1438 \$1417 GND GND sg13_lv_nmos L=0.13u W=0.3u AS=0.0525p
+ AD=0.331736842105p PS=0.65u PD=2.24315789474u rfmode=0
M$1289 \$1435 \$1418 GND GND sg13_lv_nmos L=0.13u W=0.3u AS=0.0525p
+ AD=0.331736842105p PS=0.65u PD=2.24315789474u rfmode=0
M$1290 \$1432 \$1419 GND GND sg13_lv_nmos L=0.13u W=0.3u AS=0.0525p
+ AD=0.331736842105p PS=0.65u PD=2.24315789474u rfmode=0
M$1291 \$1430 \$1420 GND GND sg13_lv_nmos L=0.13u W=0.3u AS=0.0525p
+ AD=0.331736842105p PS=0.65u PD=2.24315789474u rfmode=0
M$1292 \$1427 \$1421 GND GND sg13_lv_nmos L=0.13u W=0.3u AS=0.0525p
+ AD=0.331736842105p PS=0.65u PD=2.24315789474u rfmode=0
M$1293 GND \$1462 \$1507 GND sg13_lv_nmos L=0.13u W=0.3u AS=0.331736842105p
+ AD=0.0525p PS=2.24315789474u PD=0.65u rfmode=0
M$1294 GND \$1463 \$1509 GND sg13_lv_nmos L=0.13u W=0.3u AS=0.331736842105p
+ AD=0.0525p PS=2.24315789474u PD=0.65u rfmode=0
M$1295 GND \$1464 \$1510 GND sg13_lv_nmos L=0.13u W=0.3u AS=0.331736842105p
+ AD=0.0525p PS=2.24315789474u PD=0.65u rfmode=0
M$1296 GND \$1465 \$1512 GND sg13_lv_nmos L=0.13u W=0.3u AS=0.331736842105p
+ AD=0.0525p PS=2.24315789474u PD=0.65u rfmode=0
M$1297 GND \$1466 \$1514 GND sg13_lv_nmos L=0.13u W=0.3u AS=0.331736842105p
+ AD=0.0525p PS=2.24315789474u PD=0.65u rfmode=0
M$1298 GND \$1467 \$1516 GND sg13_lv_nmos L=0.13u W=0.3u AS=0.331736842105p
+ AD=0.0525p PS=2.24315789474u PD=0.65u rfmode=0
M$1299 GND \$1468 \$1517 GND sg13_lv_nmos L=0.13u W=0.3u AS=0.331736842105p
+ AD=0.0525p PS=2.24315789474u PD=0.65u rfmode=0
M$1300 GND \$1469 \$1519 GND sg13_lv_nmos L=0.13u W=0.3u AS=0.331736842105p
+ AD=0.0525p PS=2.24315789474u PD=0.65u rfmode=0
M$1301 GND \$1470 \$1520 GND sg13_lv_nmos L=0.13u W=0.3u AS=0.331736842105p
+ AD=0.0525p PS=2.24315789474u PD=0.65u rfmode=0
M$1302 GND \$1471 \$1522 GND sg13_lv_nmos L=0.13u W=0.3u AS=0.331736842105p
+ AD=0.0525p PS=2.24315789474u PD=0.65u rfmode=0
M$1303 GND \$1472 \$1523 GND sg13_lv_nmos L=0.13u W=0.3u AS=0.331736842105p
+ AD=0.0525p PS=2.24315789474u PD=0.65u rfmode=0
M$1304 GND \$1473 \$1525 GND sg13_lv_nmos L=0.13u W=0.3u AS=0.331736842105p
+ AD=0.0525p PS=2.24315789474u PD=0.65u rfmode=0
M$1305 GND \$1474 \$1527 GND sg13_lv_nmos L=0.13u W=0.3u AS=0.331736842105p
+ AD=0.0525p PS=2.24315789474u PD=0.65u rfmode=0
M$1306 GND \$1475 \$1528 GND sg13_lv_nmos L=0.13u W=0.3u AS=0.331736842105p
+ AD=0.0525p PS=2.24315789474u PD=0.65u rfmode=0
M$1307 GND \$1476 \$1530 GND sg13_lv_nmos L=0.13u W=0.3u AS=0.331736842105p
+ AD=0.0525p PS=2.24315789474u PD=0.65u rfmode=0
M$1308 GND \$1477 \$1532 GND sg13_lv_nmos L=0.13u W=0.3u AS=0.331736842105p
+ AD=0.0525p PS=2.24315789474u PD=0.65u rfmode=0
M$1309 GND \$1478 \$1533 GND sg13_lv_nmos L=0.13u W=0.3u AS=0.331736842105p
+ AD=0.0525p PS=2.24315789474u PD=0.65u rfmode=0
M$1310 GND \$1479 \$1535 GND sg13_lv_nmos L=0.13u W=0.3u AS=0.331736842105p
+ AD=0.0525p PS=2.24315789474u PD=0.65u rfmode=0
M$1311 GND \$1480 \$1536 GND sg13_lv_nmos L=0.13u W=0.3u AS=0.331736842105p
+ AD=0.0525p PS=2.24315789474u PD=0.65u rfmode=0
M$1312 \$1507 RWL[17] RBL[0] GND sg13_lv_nmos L=0.13u W=0.3u AS=0.0525p
+ AD=0.057p PS=0.65u PD=0.68u rfmode=0
M$1313 \$1509 RWL[17] RBL[1] GND sg13_lv_nmos L=0.13u W=0.3u AS=0.0525p
+ AD=0.057p PS=0.65u PD=0.68u rfmode=0
M$1314 \$1510 RWL[17] RBL[2] GND sg13_lv_nmos L=0.13u W=0.3u AS=0.0525p
+ AD=0.057p PS=0.65u PD=0.68u rfmode=0
M$1315 \$1512 RWL[17] RBL[3] GND sg13_lv_nmos L=0.13u W=0.3u AS=0.0525p
+ AD=0.057p PS=0.65u PD=0.68u rfmode=0
M$1316 \$1514 RWL[17] RBL[4] GND sg13_lv_nmos L=0.13u W=0.3u AS=0.0525p
+ AD=0.057p PS=0.65u PD=0.68u rfmode=0
M$1317 \$1516 RWL[17] RBL[5] GND sg13_lv_nmos L=0.13u W=0.3u AS=0.0525p
+ AD=0.057p PS=0.65u PD=0.68u rfmode=0
M$1318 \$1517 RWL[17] RBL[6] GND sg13_lv_nmos L=0.13u W=0.3u AS=0.0525p
+ AD=0.057p PS=0.65u PD=0.68u rfmode=0
M$1319 \$1519 RWL[17] RBL[7] GND sg13_lv_nmos L=0.13u W=0.3u AS=0.0525p
+ AD=0.057p PS=0.65u PD=0.68u rfmode=0
M$1320 \$1520 RWL[17] RBL[8] GND sg13_lv_nmos L=0.13u W=0.3u AS=0.0525p
+ AD=0.057p PS=0.65u PD=0.68u rfmode=0
M$1321 \$1522 RWL[17] RBL[9] GND sg13_lv_nmos L=0.13u W=0.3u AS=0.0525p
+ AD=0.057p PS=0.65u PD=0.68u rfmode=0
M$1322 \$1523 RWL[17] RBL[10] GND sg13_lv_nmos L=0.13u W=0.3u AS=0.0525p
+ AD=0.057p PS=0.65u PD=0.68u rfmode=0
M$1323 \$1525 RWL[17] RBL[11] GND sg13_lv_nmos L=0.13u W=0.3u AS=0.0525p
+ AD=0.057p PS=0.65u PD=0.68u rfmode=0
M$1324 \$1527 RWL[17] RBL[12] GND sg13_lv_nmos L=0.13u W=0.3u AS=0.0525p
+ AD=0.057p PS=0.65u PD=0.68u rfmode=0
M$1325 \$1528 RWL[17] RBL[13] GND sg13_lv_nmos L=0.13u W=0.3u AS=0.0525p
+ AD=0.057p PS=0.65u PD=0.68u rfmode=0
M$1326 \$1530 RWL[17] RBL[14] GND sg13_lv_nmos L=0.13u W=0.3u AS=0.0525p
+ AD=0.057p PS=0.65u PD=0.68u rfmode=0
M$1327 \$1532 RWL[17] RBL[15] GND sg13_lv_nmos L=0.13u W=0.3u AS=0.0525p
+ AD=0.057p PS=0.65u PD=0.68u rfmode=0
M$1328 \$1533 RWL[17] RBL[16] GND sg13_lv_nmos L=0.13u W=0.3u AS=0.0525p
+ AD=0.057p PS=0.65u PD=0.68u rfmode=0
M$1329 \$1535 RWL[17] RBL[17] GND sg13_lv_nmos L=0.13u W=0.3u AS=0.0525p
+ AD=0.057p PS=0.65u PD=0.68u rfmode=0
M$1330 \$1536 RWL[17] RBL[18] GND sg13_lv_nmos L=0.13u W=0.3u AS=0.0525p
+ AD=0.057p PS=0.65u PD=0.68u rfmode=0
M$1331 RBL[0] RWL[18] \$1587 GND sg13_lv_nmos L=0.13u W=0.3u AS=0.057p
+ AD=0.0525p PS=0.68u PD=0.65u rfmode=0
M$1332 RBL[1] RWL[18] \$1588 GND sg13_lv_nmos L=0.13u W=0.3u AS=0.057p
+ AD=0.0525p PS=0.68u PD=0.65u rfmode=0
M$1333 RBL[2] RWL[18] \$1589 GND sg13_lv_nmos L=0.13u W=0.3u AS=0.057p
+ AD=0.0525p PS=0.68u PD=0.65u rfmode=0
M$1334 RBL[3] RWL[18] \$1591 GND sg13_lv_nmos L=0.13u W=0.3u AS=0.057p
+ AD=0.0525p PS=0.68u PD=0.65u rfmode=0
M$1335 RBL[4] RWL[18] \$1593 GND sg13_lv_nmos L=0.13u W=0.3u AS=0.057p
+ AD=0.0525p PS=0.68u PD=0.65u rfmode=0
M$1336 RBL[5] RWL[18] \$1594 GND sg13_lv_nmos L=0.13u W=0.3u AS=0.057p
+ AD=0.0525p PS=0.68u PD=0.65u rfmode=0
M$1337 RBL[6] RWL[18] \$1596 GND sg13_lv_nmos L=0.13u W=0.3u AS=0.057p
+ AD=0.0525p PS=0.68u PD=0.65u rfmode=0
M$1338 RBL[7] RWL[18] \$1597 GND sg13_lv_nmos L=0.13u W=0.3u AS=0.057p
+ AD=0.0525p PS=0.68u PD=0.65u rfmode=0
M$1339 RBL[8] RWL[18] \$1599 GND sg13_lv_nmos L=0.13u W=0.3u AS=0.057p
+ AD=0.0525p PS=0.68u PD=0.65u rfmode=0
M$1340 RBL[9] RWL[18] \$1601 GND sg13_lv_nmos L=0.13u W=0.3u AS=0.057p
+ AD=0.0525p PS=0.68u PD=0.65u rfmode=0
M$1341 RBL[10] RWL[18] \$1602 GND sg13_lv_nmos L=0.13u W=0.3u AS=0.057p
+ AD=0.0525p PS=0.68u PD=0.65u rfmode=0
M$1342 RBL[11] RWL[18] \$1604 GND sg13_lv_nmos L=0.13u W=0.3u AS=0.057p
+ AD=0.0525p PS=0.68u PD=0.65u rfmode=0
M$1343 RBL[12] RWL[18] \$1606 GND sg13_lv_nmos L=0.13u W=0.3u AS=0.057p
+ AD=0.0525p PS=0.68u PD=0.65u rfmode=0
M$1344 RBL[13] RWL[18] \$1607 GND sg13_lv_nmos L=0.13u W=0.3u AS=0.057p
+ AD=0.0525p PS=0.68u PD=0.65u rfmode=0
M$1345 RBL[14] RWL[18] \$1609 GND sg13_lv_nmos L=0.13u W=0.3u AS=0.057p
+ AD=0.0525p PS=0.68u PD=0.65u rfmode=0
M$1346 RBL[15] RWL[18] \$1610 GND sg13_lv_nmos L=0.13u W=0.3u AS=0.057p
+ AD=0.0525p PS=0.68u PD=0.65u rfmode=0
M$1347 RBL[16] RWL[18] \$1612 GND sg13_lv_nmos L=0.13u W=0.3u AS=0.057p
+ AD=0.0525p PS=0.68u PD=0.65u rfmode=0
M$1348 RBL[17] RWL[18] \$1614 GND sg13_lv_nmos L=0.13u W=0.3u AS=0.057p
+ AD=0.0525p PS=0.68u PD=0.65u rfmode=0
M$1349 RBL[18] RWL[18] \$1615 GND sg13_lv_nmos L=0.13u W=0.3u AS=0.057p
+ AD=0.0525p PS=0.68u PD=0.65u rfmode=0
M$1350 \$1587 \$1547 GND GND sg13_lv_nmos L=0.13u W=0.3u AS=0.0525p
+ AD=0.331736842105p PS=0.65u PD=2.24315789474u rfmode=0
M$1351 \$1588 \$1548 GND GND sg13_lv_nmos L=0.13u W=0.3u AS=0.0525p
+ AD=0.331736842105p PS=0.65u PD=2.24315789474u rfmode=0
M$1352 \$1589 \$1549 GND GND sg13_lv_nmos L=0.13u W=0.3u AS=0.0525p
+ AD=0.331736842105p PS=0.65u PD=2.24315789474u rfmode=0
M$1353 \$1591 \$1550 GND GND sg13_lv_nmos L=0.13u W=0.3u AS=0.0525p
+ AD=0.331736842105p PS=0.65u PD=2.24315789474u rfmode=0
M$1354 \$1593 \$1551 GND GND sg13_lv_nmos L=0.13u W=0.3u AS=0.0525p
+ AD=0.331736842105p PS=0.65u PD=2.24315789474u rfmode=0
M$1355 \$1594 \$1552 GND GND sg13_lv_nmos L=0.13u W=0.3u AS=0.0525p
+ AD=0.331736842105p PS=0.65u PD=2.24315789474u rfmode=0
M$1356 \$1596 \$1553 GND GND sg13_lv_nmos L=0.13u W=0.3u AS=0.0525p
+ AD=0.331736842105p PS=0.65u PD=2.24315789474u rfmode=0
M$1357 \$1597 \$1554 GND GND sg13_lv_nmos L=0.13u W=0.3u AS=0.0525p
+ AD=0.331736842105p PS=0.65u PD=2.24315789474u rfmode=0
M$1358 \$1599 \$1555 GND GND sg13_lv_nmos L=0.13u W=0.3u AS=0.0525p
+ AD=0.331736842105p PS=0.65u PD=2.24315789474u rfmode=0
M$1359 \$1601 \$1556 GND GND sg13_lv_nmos L=0.13u W=0.3u AS=0.0525p
+ AD=0.331736842105p PS=0.65u PD=2.24315789474u rfmode=0
M$1360 \$1602 \$1557 GND GND sg13_lv_nmos L=0.13u W=0.3u AS=0.0525p
+ AD=0.331736842105p PS=0.65u PD=2.24315789474u rfmode=0
M$1361 \$1604 \$1558 GND GND sg13_lv_nmos L=0.13u W=0.3u AS=0.0525p
+ AD=0.331736842105p PS=0.65u PD=2.24315789474u rfmode=0
M$1362 \$1606 \$1559 GND GND sg13_lv_nmos L=0.13u W=0.3u AS=0.0525p
+ AD=0.331736842105p PS=0.65u PD=2.24315789474u rfmode=0
M$1363 \$1607 \$1560 GND GND sg13_lv_nmos L=0.13u W=0.3u AS=0.0525p
+ AD=0.331736842105p PS=0.65u PD=2.24315789474u rfmode=0
M$1364 \$1609 \$1561 GND GND sg13_lv_nmos L=0.13u W=0.3u AS=0.0525p
+ AD=0.331736842105p PS=0.65u PD=2.24315789474u rfmode=0
M$1365 \$1610 \$1562 GND GND sg13_lv_nmos L=0.13u W=0.3u AS=0.0525p
+ AD=0.331736842105p PS=0.65u PD=2.24315789474u rfmode=0
M$1366 \$1612 \$1563 GND GND sg13_lv_nmos L=0.13u W=0.3u AS=0.0525p
+ AD=0.331736842105p PS=0.65u PD=2.24315789474u rfmode=0
M$1367 \$1614 \$1564 GND GND sg13_lv_nmos L=0.13u W=0.3u AS=0.0525p
+ AD=0.331736842105p PS=0.65u PD=2.24315789474u rfmode=0
M$1368 \$1615 \$1565 GND GND sg13_lv_nmos L=0.13u W=0.3u AS=0.0525p
+ AD=0.331736842105p PS=0.65u PD=2.24315789474u rfmode=0
M$1369 GND \$1481 \$1539 GND sg13_lv_nmos L=0.13u W=0.3u AS=0.331736842105p
+ AD=0.0525p PS=2.24315789474u PD=0.65u rfmode=0
M$1370 GND \$1482 \$1540 GND sg13_lv_nmos L=0.13u W=0.3u AS=0.331736842105p
+ AD=0.0525p PS=2.24315789474u PD=0.65u rfmode=0
M$1371 GND \$1483 \$1542 GND sg13_lv_nmos L=0.13u W=0.3u AS=0.331736842105p
+ AD=0.0525p PS=2.24315789474u PD=0.65u rfmode=0
M$1372 GND \$1484 \$1543 GND sg13_lv_nmos L=0.13u W=0.3u AS=0.331736842105p
+ AD=0.0525p PS=2.24315789474u PD=0.65u rfmode=0
M$1373 GND \$1485 \$1541 GND sg13_lv_nmos L=0.13u W=0.3u AS=0.331736842105p
+ AD=0.0525p PS=2.24315789474u PD=0.65u rfmode=0
M$1374 GND \$1486 \$1538 GND sg13_lv_nmos L=0.13u W=0.3u AS=0.331736842105p
+ AD=0.0525p PS=2.24315789474u PD=0.65u rfmode=0
M$1375 GND \$1487 \$1537 GND sg13_lv_nmos L=0.13u W=0.3u AS=0.331736842105p
+ AD=0.0525p PS=2.24315789474u PD=0.65u rfmode=0
M$1376 GND \$1488 \$1534 GND sg13_lv_nmos L=0.13u W=0.3u AS=0.331736842105p
+ AD=0.0525p PS=2.24315789474u PD=0.65u rfmode=0
M$1377 GND \$1489 \$1531 GND sg13_lv_nmos L=0.13u W=0.3u AS=0.331736842105p
+ AD=0.0525p PS=2.24315789474u PD=0.65u rfmode=0
M$1378 GND \$1490 \$1529 GND sg13_lv_nmos L=0.13u W=0.3u AS=0.331736842105p
+ AD=0.0525p PS=2.24315789474u PD=0.65u rfmode=0
M$1379 GND \$1491 \$1526 GND sg13_lv_nmos L=0.13u W=0.3u AS=0.331736842105p
+ AD=0.0525p PS=2.24315789474u PD=0.65u rfmode=0
M$1380 GND \$1492 \$1524 GND sg13_lv_nmos L=0.13u W=0.3u AS=0.331736842105p
+ AD=0.0525p PS=2.24315789474u PD=0.65u rfmode=0
M$1381 GND \$1493 \$1521 GND sg13_lv_nmos L=0.13u W=0.3u AS=0.331736842105p
+ AD=0.0525p PS=2.24315789474u PD=0.65u rfmode=0
M$1382 GND \$1494 \$1518 GND sg13_lv_nmos L=0.13u W=0.3u AS=0.331736842105p
+ AD=0.0525p PS=2.24315789474u PD=0.65u rfmode=0
M$1383 GND \$1495 \$1515 GND sg13_lv_nmos L=0.13u W=0.3u AS=0.331736842105p
+ AD=0.0525p PS=2.24315789474u PD=0.65u rfmode=0
M$1384 GND \$1496 \$1513 GND sg13_lv_nmos L=0.13u W=0.3u AS=0.331736842105p
+ AD=0.0525p PS=2.24315789474u PD=0.65u rfmode=0
M$1385 GND \$1497 \$1511 GND sg13_lv_nmos L=0.13u W=0.3u AS=0.331736842105p
+ AD=0.0525p PS=2.24315789474u PD=0.65u rfmode=0
M$1386 GND \$1498 \$1508 GND sg13_lv_nmos L=0.13u W=0.3u AS=0.331736842105p
+ AD=0.0525p PS=2.24315789474u PD=0.65u rfmode=0
M$1387 GND \$1499 \$1506 GND sg13_lv_nmos L=0.13u W=0.3u AS=0.331736842105p
+ AD=0.0525p PS=2.24315789474u PD=0.65u rfmode=0
M$1388 \$1539 RWL[17] RBL[19] GND sg13_lv_nmos L=0.13u W=0.3u AS=0.0525p
+ AD=0.057p PS=0.65u PD=0.68u rfmode=0
M$1389 \$1540 RWL[17] RBL[20] GND sg13_lv_nmos L=0.13u W=0.3u AS=0.0525p
+ AD=0.057p PS=0.65u PD=0.68u rfmode=0
M$1390 \$1542 RWL[17] RBL[21] GND sg13_lv_nmos L=0.13u W=0.3u AS=0.0525p
+ AD=0.057p PS=0.65u PD=0.68u rfmode=0
M$1391 \$1543 RWL[17] RBL[22] GND sg13_lv_nmos L=0.13u W=0.3u AS=0.0525p
+ AD=0.057p PS=0.65u PD=0.68u rfmode=0
M$1392 \$1541 RWL[17] RBL[23] GND sg13_lv_nmos L=0.13u W=0.3u AS=0.0525p
+ AD=0.057p PS=0.65u PD=0.68u rfmode=0
M$1393 \$1538 RWL[17] RBL[24] GND sg13_lv_nmos L=0.13u W=0.3u AS=0.0525p
+ AD=0.057p PS=0.65u PD=0.68u rfmode=0
M$1394 \$1537 RWL[17] RBL[25] GND sg13_lv_nmos L=0.13u W=0.3u AS=0.0525p
+ AD=0.057p PS=0.65u PD=0.68u rfmode=0
M$1395 \$1534 RWL[17] RBL[26] GND sg13_lv_nmos L=0.13u W=0.3u AS=0.0525p
+ AD=0.057p PS=0.65u PD=0.68u rfmode=0
M$1396 \$1531 RWL[17] RBL[27] GND sg13_lv_nmos L=0.13u W=0.3u AS=0.0525p
+ AD=0.057p PS=0.65u PD=0.68u rfmode=0
M$1397 \$1529 RWL[17] RBL[28] GND sg13_lv_nmos L=0.13u W=0.3u AS=0.0525p
+ AD=0.057p PS=0.65u PD=0.68u rfmode=0
M$1398 \$1526 RWL[17] RBL[29] GND sg13_lv_nmos L=0.13u W=0.3u AS=0.0525p
+ AD=0.057p PS=0.65u PD=0.68u rfmode=0
M$1399 \$1524 RWL[17] RBL[30] GND sg13_lv_nmos L=0.13u W=0.3u AS=0.0525p
+ AD=0.057p PS=0.65u PD=0.68u rfmode=0
M$1400 \$1521 RWL[17] RBL[31] GND sg13_lv_nmos L=0.13u W=0.3u AS=0.0525p
+ AD=0.057p PS=0.65u PD=0.68u rfmode=0
M$1401 \$1518 RWL[17] RBL[32] GND sg13_lv_nmos L=0.13u W=0.3u AS=0.0525p
+ AD=0.057p PS=0.65u PD=0.68u rfmode=0
M$1402 \$1515 RWL[17] RBL[33] GND sg13_lv_nmos L=0.13u W=0.3u AS=0.0525p
+ AD=0.057p PS=0.65u PD=0.68u rfmode=0
M$1403 \$1513 RWL[17] RBL[34] GND sg13_lv_nmos L=0.13u W=0.3u AS=0.0525p
+ AD=0.057p PS=0.65u PD=0.68u rfmode=0
M$1404 \$1511 RWL[17] RBL[35] GND sg13_lv_nmos L=0.13u W=0.3u AS=0.0525p
+ AD=0.057p PS=0.65u PD=0.68u rfmode=0
M$1405 \$1508 RWL[17] RBL[36] GND sg13_lv_nmos L=0.13u W=0.3u AS=0.0525p
+ AD=0.057p PS=0.65u PD=0.68u rfmode=0
M$1406 \$1506 RWL[17] RBL[37] GND sg13_lv_nmos L=0.13u W=0.3u AS=0.0525p
+ AD=0.057p PS=0.65u PD=0.68u rfmode=0
M$1407 RBL[19] RWL[18] \$1618 GND sg13_lv_nmos L=0.13u W=0.3u AS=0.057p
+ AD=0.0525p PS=0.68u PD=0.65u rfmode=0
M$1408 RBL[20] RWL[18] \$1619 GND sg13_lv_nmos L=0.13u W=0.3u AS=0.057p
+ AD=0.0525p PS=0.68u PD=0.65u rfmode=0
M$1409 RBL[21] RWL[18] \$1621 GND sg13_lv_nmos L=0.13u W=0.3u AS=0.057p
+ AD=0.0525p PS=0.68u PD=0.65u rfmode=0
M$1410 RBL[22] RWL[18] \$1623 GND sg13_lv_nmos L=0.13u W=0.3u AS=0.057p
+ AD=0.0525p PS=0.68u PD=0.65u rfmode=0
M$1411 RBL[23] RWL[18] \$1624 GND sg13_lv_nmos L=0.13u W=0.3u AS=0.057p
+ AD=0.0525p PS=0.68u PD=0.65u rfmode=0
M$1412 RBL[24] RWL[18] \$1622 GND sg13_lv_nmos L=0.13u W=0.3u AS=0.057p
+ AD=0.0525p PS=0.68u PD=0.65u rfmode=0
M$1413 RBL[25] RWL[18] \$1620 GND sg13_lv_nmos L=0.13u W=0.3u AS=0.057p
+ AD=0.0525p PS=0.68u PD=0.65u rfmode=0
M$1414 RBL[26] RWL[18] \$1617 GND sg13_lv_nmos L=0.13u W=0.3u AS=0.057p
+ AD=0.0525p PS=0.68u PD=0.65u rfmode=0
M$1415 RBL[27] RWL[18] \$1616 GND sg13_lv_nmos L=0.13u W=0.3u AS=0.057p
+ AD=0.0525p PS=0.68u PD=0.65u rfmode=0
M$1416 RBL[28] RWL[18] \$1613 GND sg13_lv_nmos L=0.13u W=0.3u AS=0.057p
+ AD=0.0525p PS=0.68u PD=0.65u rfmode=0
M$1417 RBL[29] RWL[18] \$1611 GND sg13_lv_nmos L=0.13u W=0.3u AS=0.057p
+ AD=0.0525p PS=0.68u PD=0.65u rfmode=0
M$1418 RBL[30] RWL[18] \$1608 GND sg13_lv_nmos L=0.13u W=0.3u AS=0.057p
+ AD=0.0525p PS=0.68u PD=0.65u rfmode=0
M$1419 RBL[31] RWL[18] \$1605 GND sg13_lv_nmos L=0.13u W=0.3u AS=0.057p
+ AD=0.0525p PS=0.68u PD=0.65u rfmode=0
M$1420 RBL[32] RWL[18] \$1603 GND sg13_lv_nmos L=0.13u W=0.3u AS=0.057p
+ AD=0.0525p PS=0.68u PD=0.65u rfmode=0
M$1421 RBL[33] RWL[18] \$1600 GND sg13_lv_nmos L=0.13u W=0.3u AS=0.057p
+ AD=0.0525p PS=0.68u PD=0.65u rfmode=0
M$1422 RBL[34] RWL[18] \$1598 GND sg13_lv_nmos L=0.13u W=0.3u AS=0.057p
+ AD=0.0525p PS=0.68u PD=0.65u rfmode=0
M$1423 RBL[35] RWL[18] \$1595 GND sg13_lv_nmos L=0.13u W=0.3u AS=0.057p
+ AD=0.0525p PS=0.68u PD=0.65u rfmode=0
M$1424 RBL[36] RWL[18] \$1592 GND sg13_lv_nmos L=0.13u W=0.3u AS=0.057p
+ AD=0.0525p PS=0.68u PD=0.65u rfmode=0
M$1425 RBL[37] RWL[18] \$1590 GND sg13_lv_nmos L=0.13u W=0.3u AS=0.057p
+ AD=0.0525p PS=0.68u PD=0.65u rfmode=0
M$1426 \$1618 \$1566 GND GND sg13_lv_nmos L=0.13u W=0.3u AS=0.0525p
+ AD=0.331736842105p PS=0.65u PD=2.24315789474u rfmode=0
M$1427 \$1619 \$1567 GND GND sg13_lv_nmos L=0.13u W=0.3u AS=0.0525p
+ AD=0.331736842105p PS=0.65u PD=2.24315789474u rfmode=0
M$1428 \$1621 \$1568 GND GND sg13_lv_nmos L=0.13u W=0.3u AS=0.0525p
+ AD=0.331736842105p PS=0.65u PD=2.24315789474u rfmode=0
M$1429 \$1623 \$1569 GND GND sg13_lv_nmos L=0.13u W=0.3u AS=0.0525p
+ AD=0.331736842105p PS=0.65u PD=2.24315789474u rfmode=0
M$1430 \$1624 \$1570 GND GND sg13_lv_nmos L=0.13u W=0.3u AS=0.0525p
+ AD=0.331736842105p PS=0.65u PD=2.24315789474u rfmode=0
M$1431 \$1622 \$1571 GND GND sg13_lv_nmos L=0.13u W=0.3u AS=0.0525p
+ AD=0.331736842105p PS=0.65u PD=2.24315789474u rfmode=0
M$1432 \$1620 \$1572 GND GND sg13_lv_nmos L=0.13u W=0.3u AS=0.0525p
+ AD=0.331736842105p PS=0.65u PD=2.24315789474u rfmode=0
M$1433 \$1617 \$1573 GND GND sg13_lv_nmos L=0.13u W=0.3u AS=0.0525p
+ AD=0.331736842105p PS=0.65u PD=2.24315789474u rfmode=0
M$1434 \$1616 \$1574 GND GND sg13_lv_nmos L=0.13u W=0.3u AS=0.0525p
+ AD=0.331736842105p PS=0.65u PD=2.24315789474u rfmode=0
M$1435 \$1613 \$1575 GND GND sg13_lv_nmos L=0.13u W=0.3u AS=0.0525p
+ AD=0.331736842105p PS=0.65u PD=2.24315789474u rfmode=0
M$1436 \$1611 \$1576 GND GND sg13_lv_nmos L=0.13u W=0.3u AS=0.0525p
+ AD=0.331736842105p PS=0.65u PD=2.24315789474u rfmode=0
M$1437 \$1608 \$1577 GND GND sg13_lv_nmos L=0.13u W=0.3u AS=0.0525p
+ AD=0.331736842105p PS=0.65u PD=2.24315789474u rfmode=0
M$1438 \$1605 \$1578 GND GND sg13_lv_nmos L=0.13u W=0.3u AS=0.0525p
+ AD=0.331736842105p PS=0.65u PD=2.24315789474u rfmode=0
M$1439 \$1603 \$1579 GND GND sg13_lv_nmos L=0.13u W=0.3u AS=0.0525p
+ AD=0.331736842105p PS=0.65u PD=2.24315789474u rfmode=0
M$1440 \$1600 \$1580 GND GND sg13_lv_nmos L=0.13u W=0.3u AS=0.0525p
+ AD=0.331736842105p PS=0.65u PD=2.24315789474u rfmode=0
M$1441 \$1598 \$1581 GND GND sg13_lv_nmos L=0.13u W=0.3u AS=0.0525p
+ AD=0.331736842105p PS=0.65u PD=2.24315789474u rfmode=0
M$1442 \$1595 \$1582 GND GND sg13_lv_nmos L=0.13u W=0.3u AS=0.0525p
+ AD=0.331736842105p PS=0.65u PD=2.24315789474u rfmode=0
M$1443 \$1592 \$1583 GND GND sg13_lv_nmos L=0.13u W=0.3u AS=0.0525p
+ AD=0.331736842105p PS=0.65u PD=2.24315789474u rfmode=0
M$1444 \$1590 \$1584 GND GND sg13_lv_nmos L=0.13u W=0.3u AS=0.0525p
+ AD=0.331736842105p PS=0.65u PD=2.24315789474u rfmode=0
M$1445 GND \$1625 \$1670 GND sg13_lv_nmos L=0.13u W=0.3u AS=0.331736842105p
+ AD=0.0525p PS=2.24315789474u PD=0.65u rfmode=0
M$1446 GND \$1626 \$1672 GND sg13_lv_nmos L=0.13u W=0.3u AS=0.331736842105p
+ AD=0.0525p PS=2.24315789474u PD=0.65u rfmode=0
M$1447 GND \$1627 \$1674 GND sg13_lv_nmos L=0.13u W=0.3u AS=0.331736842105p
+ AD=0.0525p PS=2.24315789474u PD=0.65u rfmode=0
M$1448 GND \$1628 \$1675 GND sg13_lv_nmos L=0.13u W=0.3u AS=0.331736842105p
+ AD=0.0525p PS=2.24315789474u PD=0.65u rfmode=0
M$1449 GND \$1629 \$1677 GND sg13_lv_nmos L=0.13u W=0.3u AS=0.331736842105p
+ AD=0.0525p PS=2.24315789474u PD=0.65u rfmode=0
M$1450 GND \$1630 \$1678 GND sg13_lv_nmos L=0.13u W=0.3u AS=0.331736842105p
+ AD=0.0525p PS=2.24315789474u PD=0.65u rfmode=0
M$1451 GND \$1631 \$1680 GND sg13_lv_nmos L=0.13u W=0.3u AS=0.331736842105p
+ AD=0.0525p PS=2.24315789474u PD=0.65u rfmode=0
M$1452 GND \$1632 \$1682 GND sg13_lv_nmos L=0.13u W=0.3u AS=0.331736842105p
+ AD=0.0525p PS=2.24315789474u PD=0.65u rfmode=0
M$1453 GND \$1633 \$1683 GND sg13_lv_nmos L=0.13u W=0.3u AS=0.331736842105p
+ AD=0.0525p PS=2.24315789474u PD=0.65u rfmode=0
M$1454 GND \$1634 \$1685 GND sg13_lv_nmos L=0.13u W=0.3u AS=0.331736842105p
+ AD=0.0525p PS=2.24315789474u PD=0.65u rfmode=0
M$1455 GND \$1635 \$1687 GND sg13_lv_nmos L=0.13u W=0.3u AS=0.331736842105p
+ AD=0.0525p PS=2.24315789474u PD=0.65u rfmode=0
M$1456 GND \$1636 \$1688 GND sg13_lv_nmos L=0.13u W=0.3u AS=0.331736842105p
+ AD=0.0525p PS=2.24315789474u PD=0.65u rfmode=0
M$1457 GND \$1637 \$1690 GND sg13_lv_nmos L=0.13u W=0.3u AS=0.331736842105p
+ AD=0.0525p PS=2.24315789474u PD=0.65u rfmode=0
M$1458 GND \$1638 \$1691 GND sg13_lv_nmos L=0.13u W=0.3u AS=0.331736842105p
+ AD=0.0525p PS=2.24315789474u PD=0.65u rfmode=0
M$1459 GND \$1639 \$1693 GND sg13_lv_nmos L=0.13u W=0.3u AS=0.331736842105p
+ AD=0.0525p PS=2.24315789474u PD=0.65u rfmode=0
M$1460 GND \$1640 \$1695 GND sg13_lv_nmos L=0.13u W=0.3u AS=0.331736842105p
+ AD=0.0525p PS=2.24315789474u PD=0.65u rfmode=0
M$1461 GND \$1641 \$1696 GND sg13_lv_nmos L=0.13u W=0.3u AS=0.331736842105p
+ AD=0.0525p PS=2.24315789474u PD=0.65u rfmode=0
M$1462 GND \$1642 \$1698 GND sg13_lv_nmos L=0.13u W=0.3u AS=0.331736842105p
+ AD=0.0525p PS=2.24315789474u PD=0.65u rfmode=0
M$1463 GND \$1643 \$1699 GND sg13_lv_nmos L=0.13u W=0.3u AS=0.331736842105p
+ AD=0.0525p PS=2.24315789474u PD=0.65u rfmode=0
M$1464 \$1670 RWL[19] RBL[0] GND sg13_lv_nmos L=0.13u W=0.3u AS=0.0525p
+ AD=0.057p PS=0.65u PD=0.68u rfmode=0
M$1465 \$1672 RWL[19] RBL[1] GND sg13_lv_nmos L=0.13u W=0.3u AS=0.0525p
+ AD=0.057p PS=0.65u PD=0.68u rfmode=0
M$1466 \$1674 RWL[19] RBL[2] GND sg13_lv_nmos L=0.13u W=0.3u AS=0.0525p
+ AD=0.057p PS=0.65u PD=0.68u rfmode=0
M$1467 \$1675 RWL[19] RBL[3] GND sg13_lv_nmos L=0.13u W=0.3u AS=0.0525p
+ AD=0.057p PS=0.65u PD=0.68u rfmode=0
M$1468 \$1677 RWL[19] RBL[4] GND sg13_lv_nmos L=0.13u W=0.3u AS=0.0525p
+ AD=0.057p PS=0.65u PD=0.68u rfmode=0
M$1469 \$1678 RWL[19] RBL[5] GND sg13_lv_nmos L=0.13u W=0.3u AS=0.0525p
+ AD=0.057p PS=0.65u PD=0.68u rfmode=0
M$1470 \$1680 RWL[19] RBL[6] GND sg13_lv_nmos L=0.13u W=0.3u AS=0.0525p
+ AD=0.057p PS=0.65u PD=0.68u rfmode=0
M$1471 \$1682 RWL[19] RBL[7] GND sg13_lv_nmos L=0.13u W=0.3u AS=0.0525p
+ AD=0.057p PS=0.65u PD=0.68u rfmode=0
M$1472 \$1683 RWL[19] RBL[8] GND sg13_lv_nmos L=0.13u W=0.3u AS=0.0525p
+ AD=0.057p PS=0.65u PD=0.68u rfmode=0
M$1473 \$1685 RWL[19] RBL[9] GND sg13_lv_nmos L=0.13u W=0.3u AS=0.0525p
+ AD=0.057p PS=0.65u PD=0.68u rfmode=0
M$1474 \$1687 RWL[19] RBL[10] GND sg13_lv_nmos L=0.13u W=0.3u AS=0.0525p
+ AD=0.057p PS=0.65u PD=0.68u rfmode=0
M$1475 \$1688 RWL[19] RBL[11] GND sg13_lv_nmos L=0.13u W=0.3u AS=0.0525p
+ AD=0.057p PS=0.65u PD=0.68u rfmode=0
M$1476 \$1690 RWL[19] RBL[12] GND sg13_lv_nmos L=0.13u W=0.3u AS=0.0525p
+ AD=0.057p PS=0.65u PD=0.68u rfmode=0
M$1477 \$1691 RWL[19] RBL[13] GND sg13_lv_nmos L=0.13u W=0.3u AS=0.0525p
+ AD=0.057p PS=0.65u PD=0.68u rfmode=0
M$1478 \$1693 RWL[19] RBL[14] GND sg13_lv_nmos L=0.13u W=0.3u AS=0.0525p
+ AD=0.057p PS=0.65u PD=0.68u rfmode=0
M$1479 \$1695 RWL[19] RBL[15] GND sg13_lv_nmos L=0.13u W=0.3u AS=0.0525p
+ AD=0.057p PS=0.65u PD=0.68u rfmode=0
M$1480 \$1696 RWL[19] RBL[16] GND sg13_lv_nmos L=0.13u W=0.3u AS=0.0525p
+ AD=0.057p PS=0.65u PD=0.68u rfmode=0
M$1481 \$1698 RWL[19] RBL[17] GND sg13_lv_nmos L=0.13u W=0.3u AS=0.0525p
+ AD=0.057p PS=0.65u PD=0.68u rfmode=0
M$1482 \$1699 RWL[19] RBL[18] GND sg13_lv_nmos L=0.13u W=0.3u AS=0.0525p
+ AD=0.057p PS=0.65u PD=0.68u rfmode=0
M$1483 RBL[0] RWL[20] \$1750 GND sg13_lv_nmos L=0.13u W=0.3u AS=0.057p
+ AD=0.0525p PS=0.68u PD=0.65u rfmode=0
M$1484 RBL[1] RWL[20] \$1751 GND sg13_lv_nmos L=0.13u W=0.3u AS=0.057p
+ AD=0.0525p PS=0.68u PD=0.65u rfmode=0
M$1485 RBL[2] RWL[20] \$1752 GND sg13_lv_nmos L=0.13u W=0.3u AS=0.057p
+ AD=0.0525p PS=0.68u PD=0.65u rfmode=0
M$1486 RBL[3] RWL[20] \$1754 GND sg13_lv_nmos L=0.13u W=0.3u AS=0.057p
+ AD=0.0525p PS=0.68u PD=0.65u rfmode=0
M$1487 RBL[4] RWL[20] \$1755 GND sg13_lv_nmos L=0.13u W=0.3u AS=0.057p
+ AD=0.0525p PS=0.68u PD=0.65u rfmode=0
M$1488 RBL[5] RWL[20] \$1757 GND sg13_lv_nmos L=0.13u W=0.3u AS=0.057p
+ AD=0.0525p PS=0.68u PD=0.65u rfmode=0
M$1489 RBL[6] RWL[20] \$1759 GND sg13_lv_nmos L=0.13u W=0.3u AS=0.057p
+ AD=0.0525p PS=0.68u PD=0.65u rfmode=0
M$1490 RBL[7] RWL[20] \$1761 GND sg13_lv_nmos L=0.13u W=0.3u AS=0.057p
+ AD=0.0525p PS=0.68u PD=0.65u rfmode=0
M$1491 RBL[8] RWL[20] \$1762 GND sg13_lv_nmos L=0.13u W=0.3u AS=0.057p
+ AD=0.0525p PS=0.68u PD=0.65u rfmode=0
M$1492 RBL[9] RWL[20] \$1764 GND sg13_lv_nmos L=0.13u W=0.3u AS=0.057p
+ AD=0.0525p PS=0.68u PD=0.65u rfmode=0
M$1493 RBL[10] RWL[20] \$1766 GND sg13_lv_nmos L=0.13u W=0.3u AS=0.057p
+ AD=0.0525p PS=0.68u PD=0.65u rfmode=0
M$1494 RBL[11] RWL[20] \$1767 GND sg13_lv_nmos L=0.13u W=0.3u AS=0.057p
+ AD=0.0525p PS=0.68u PD=0.65u rfmode=0
M$1495 RBL[12] RWL[20] \$1769 GND sg13_lv_nmos L=0.13u W=0.3u AS=0.057p
+ AD=0.0525p PS=0.68u PD=0.65u rfmode=0
M$1496 RBL[13] RWL[20] \$1770 GND sg13_lv_nmos L=0.13u W=0.3u AS=0.057p
+ AD=0.0525p PS=0.68u PD=0.65u rfmode=0
M$1497 RBL[14] RWL[20] \$1772 GND sg13_lv_nmos L=0.13u W=0.3u AS=0.057p
+ AD=0.0525p PS=0.68u PD=0.65u rfmode=0
M$1498 RBL[15] RWL[20] \$1773 GND sg13_lv_nmos L=0.13u W=0.3u AS=0.057p
+ AD=0.0525p PS=0.68u PD=0.65u rfmode=0
M$1499 RBL[16] RWL[20] \$1775 GND sg13_lv_nmos L=0.13u W=0.3u AS=0.057p
+ AD=0.0525p PS=0.68u PD=0.65u rfmode=0
M$1500 RBL[17] RWL[20] \$1777 GND sg13_lv_nmos L=0.13u W=0.3u AS=0.057p
+ AD=0.0525p PS=0.68u PD=0.65u rfmode=0
M$1501 RBL[18] RWL[20] \$1778 GND sg13_lv_nmos L=0.13u W=0.3u AS=0.057p
+ AD=0.0525p PS=0.68u PD=0.65u rfmode=0
M$1502 \$1750 \$1710 GND GND sg13_lv_nmos L=0.13u W=0.3u AS=0.0525p
+ AD=0.331736842105p PS=0.65u PD=2.24315789474u rfmode=0
M$1503 \$1751 \$1711 GND GND sg13_lv_nmos L=0.13u W=0.3u AS=0.0525p
+ AD=0.331736842105p PS=0.65u PD=2.24315789474u rfmode=0
M$1504 \$1752 \$1712 GND GND sg13_lv_nmos L=0.13u W=0.3u AS=0.0525p
+ AD=0.331736842105p PS=0.65u PD=2.24315789474u rfmode=0
M$1505 \$1754 \$1713 GND GND sg13_lv_nmos L=0.13u W=0.3u AS=0.0525p
+ AD=0.331736842105p PS=0.65u PD=2.24315789474u rfmode=0
M$1506 \$1755 \$1714 GND GND sg13_lv_nmos L=0.13u W=0.3u AS=0.0525p
+ AD=0.331736842105p PS=0.65u PD=2.24315789474u rfmode=0
M$1507 \$1757 \$1715 GND GND sg13_lv_nmos L=0.13u W=0.3u AS=0.0525p
+ AD=0.331736842105p PS=0.65u PD=2.24315789474u rfmode=0
M$1508 \$1759 \$1716 GND GND sg13_lv_nmos L=0.13u W=0.3u AS=0.0525p
+ AD=0.331736842105p PS=0.65u PD=2.24315789474u rfmode=0
M$1509 \$1761 \$1717 GND GND sg13_lv_nmos L=0.13u W=0.3u AS=0.0525p
+ AD=0.331736842105p PS=0.65u PD=2.24315789474u rfmode=0
M$1510 \$1762 \$1718 GND GND sg13_lv_nmos L=0.13u W=0.3u AS=0.0525p
+ AD=0.331736842105p PS=0.65u PD=2.24315789474u rfmode=0
M$1511 \$1764 \$1719 GND GND sg13_lv_nmos L=0.13u W=0.3u AS=0.0525p
+ AD=0.331736842105p PS=0.65u PD=2.24315789474u rfmode=0
M$1512 \$1766 \$1720 GND GND sg13_lv_nmos L=0.13u W=0.3u AS=0.0525p
+ AD=0.331736842105p PS=0.65u PD=2.24315789474u rfmode=0
M$1513 \$1767 \$1721 GND GND sg13_lv_nmos L=0.13u W=0.3u AS=0.0525p
+ AD=0.331736842105p PS=0.65u PD=2.24315789474u rfmode=0
M$1514 \$1769 \$1722 GND GND sg13_lv_nmos L=0.13u W=0.3u AS=0.0525p
+ AD=0.331736842105p PS=0.65u PD=2.24315789474u rfmode=0
M$1515 \$1770 \$1723 GND GND sg13_lv_nmos L=0.13u W=0.3u AS=0.0525p
+ AD=0.331736842105p PS=0.65u PD=2.24315789474u rfmode=0
M$1516 \$1772 \$1724 GND GND sg13_lv_nmos L=0.13u W=0.3u AS=0.0525p
+ AD=0.331736842105p PS=0.65u PD=2.24315789474u rfmode=0
M$1517 \$1773 \$1725 GND GND sg13_lv_nmos L=0.13u W=0.3u AS=0.0525p
+ AD=0.331736842105p PS=0.65u PD=2.24315789474u rfmode=0
M$1518 \$1775 \$1726 GND GND sg13_lv_nmos L=0.13u W=0.3u AS=0.0525p
+ AD=0.331736842105p PS=0.65u PD=2.24315789474u rfmode=0
M$1519 \$1777 \$1727 GND GND sg13_lv_nmos L=0.13u W=0.3u AS=0.0525p
+ AD=0.331736842105p PS=0.65u PD=2.24315789474u rfmode=0
M$1520 \$1778 \$1728 GND GND sg13_lv_nmos L=0.13u W=0.3u AS=0.0525p
+ AD=0.331736842105p PS=0.65u PD=2.24315789474u rfmode=0
M$1521 GND \$1644 \$1702 GND sg13_lv_nmos L=0.13u W=0.3u AS=0.331736842105p
+ AD=0.0525p PS=2.24315789474u PD=0.65u rfmode=0
M$1522 GND \$1645 \$1703 GND sg13_lv_nmos L=0.13u W=0.3u AS=0.331736842105p
+ AD=0.0525p PS=2.24315789474u PD=0.65u rfmode=0
M$1523 GND \$1646 \$1705 GND sg13_lv_nmos L=0.13u W=0.3u AS=0.331736842105p
+ AD=0.0525p PS=2.24315789474u PD=0.65u rfmode=0
M$1524 GND \$1647 \$1706 GND sg13_lv_nmos L=0.13u W=0.3u AS=0.331736842105p
+ AD=0.0525p PS=2.24315789474u PD=0.65u rfmode=0
M$1525 GND \$1648 \$1704 GND sg13_lv_nmos L=0.13u W=0.3u AS=0.331736842105p
+ AD=0.0525p PS=2.24315789474u PD=0.65u rfmode=0
M$1526 GND \$1649 \$1701 GND sg13_lv_nmos L=0.13u W=0.3u AS=0.331736842105p
+ AD=0.0525p PS=2.24315789474u PD=0.65u rfmode=0
M$1527 GND \$1650 \$1700 GND sg13_lv_nmos L=0.13u W=0.3u AS=0.331736842105p
+ AD=0.0525p PS=2.24315789474u PD=0.65u rfmode=0
M$1528 GND \$1651 \$1697 GND sg13_lv_nmos L=0.13u W=0.3u AS=0.331736842105p
+ AD=0.0525p PS=2.24315789474u PD=0.65u rfmode=0
M$1529 GND \$1652 \$1694 GND sg13_lv_nmos L=0.13u W=0.3u AS=0.331736842105p
+ AD=0.0525p PS=2.24315789474u PD=0.65u rfmode=0
M$1530 GND \$1653 \$1692 GND sg13_lv_nmos L=0.13u W=0.3u AS=0.331736842105p
+ AD=0.0525p PS=2.24315789474u PD=0.65u rfmode=0
M$1531 GND \$1654 \$1689 GND sg13_lv_nmos L=0.13u W=0.3u AS=0.331736842105p
+ AD=0.0525p PS=2.24315789474u PD=0.65u rfmode=0
M$1532 GND \$1655 \$1686 GND sg13_lv_nmos L=0.13u W=0.3u AS=0.331736842105p
+ AD=0.0525p PS=2.24315789474u PD=0.65u rfmode=0
M$1533 GND \$1656 \$1684 GND sg13_lv_nmos L=0.13u W=0.3u AS=0.331736842105p
+ AD=0.0525p PS=2.24315789474u PD=0.65u rfmode=0
M$1534 GND \$1657 \$1681 GND sg13_lv_nmos L=0.13u W=0.3u AS=0.331736842105p
+ AD=0.0525p PS=2.24315789474u PD=0.65u rfmode=0
M$1535 GND \$1658 \$1679 GND sg13_lv_nmos L=0.13u W=0.3u AS=0.331736842105p
+ AD=0.0525p PS=2.24315789474u PD=0.65u rfmode=0
M$1536 GND \$1659 \$1676 GND sg13_lv_nmos L=0.13u W=0.3u AS=0.331736842105p
+ AD=0.0525p PS=2.24315789474u PD=0.65u rfmode=0
M$1537 GND \$1660 \$1673 GND sg13_lv_nmos L=0.13u W=0.3u AS=0.331736842105p
+ AD=0.0525p PS=2.24315789474u PD=0.65u rfmode=0
M$1538 GND \$1661 \$1671 GND sg13_lv_nmos L=0.13u W=0.3u AS=0.331736842105p
+ AD=0.0525p PS=2.24315789474u PD=0.65u rfmode=0
M$1539 GND \$1662 \$1669 GND sg13_lv_nmos L=0.13u W=0.3u AS=0.331736842105p
+ AD=0.0525p PS=2.24315789474u PD=0.65u rfmode=0
M$1540 \$1702 RWL[19] RBL[19] GND sg13_lv_nmos L=0.13u W=0.3u AS=0.0525p
+ AD=0.057p PS=0.65u PD=0.68u rfmode=0
M$1541 \$1703 RWL[19] RBL[20] GND sg13_lv_nmos L=0.13u W=0.3u AS=0.0525p
+ AD=0.057p PS=0.65u PD=0.68u rfmode=0
M$1542 \$1705 RWL[19] RBL[21] GND sg13_lv_nmos L=0.13u W=0.3u AS=0.0525p
+ AD=0.057p PS=0.65u PD=0.68u rfmode=0
M$1543 \$1706 RWL[19] RBL[22] GND sg13_lv_nmos L=0.13u W=0.3u AS=0.0525p
+ AD=0.057p PS=0.65u PD=0.68u rfmode=0
M$1544 \$1704 RWL[19] RBL[23] GND sg13_lv_nmos L=0.13u W=0.3u AS=0.0525p
+ AD=0.057p PS=0.65u PD=0.68u rfmode=0
M$1545 \$1701 RWL[19] RBL[24] GND sg13_lv_nmos L=0.13u W=0.3u AS=0.0525p
+ AD=0.057p PS=0.65u PD=0.68u rfmode=0
M$1546 \$1700 RWL[19] RBL[25] GND sg13_lv_nmos L=0.13u W=0.3u AS=0.0525p
+ AD=0.057p PS=0.65u PD=0.68u rfmode=0
M$1547 \$1697 RWL[19] RBL[26] GND sg13_lv_nmos L=0.13u W=0.3u AS=0.0525p
+ AD=0.057p PS=0.65u PD=0.68u rfmode=0
M$1548 \$1694 RWL[19] RBL[27] GND sg13_lv_nmos L=0.13u W=0.3u AS=0.0525p
+ AD=0.057p PS=0.65u PD=0.68u rfmode=0
M$1549 \$1692 RWL[19] RBL[28] GND sg13_lv_nmos L=0.13u W=0.3u AS=0.0525p
+ AD=0.057p PS=0.65u PD=0.68u rfmode=0
M$1550 \$1689 RWL[19] RBL[29] GND sg13_lv_nmos L=0.13u W=0.3u AS=0.0525p
+ AD=0.057p PS=0.65u PD=0.68u rfmode=0
M$1551 \$1686 RWL[19] RBL[30] GND sg13_lv_nmos L=0.13u W=0.3u AS=0.0525p
+ AD=0.057p PS=0.65u PD=0.68u rfmode=0
M$1552 \$1684 RWL[19] RBL[31] GND sg13_lv_nmos L=0.13u W=0.3u AS=0.0525p
+ AD=0.057p PS=0.65u PD=0.68u rfmode=0
M$1553 \$1681 RWL[19] RBL[32] GND sg13_lv_nmos L=0.13u W=0.3u AS=0.0525p
+ AD=0.057p PS=0.65u PD=0.68u rfmode=0
M$1554 \$1679 RWL[19] RBL[33] GND sg13_lv_nmos L=0.13u W=0.3u AS=0.0525p
+ AD=0.057p PS=0.65u PD=0.68u rfmode=0
M$1555 \$1676 RWL[19] RBL[34] GND sg13_lv_nmos L=0.13u W=0.3u AS=0.0525p
+ AD=0.057p PS=0.65u PD=0.68u rfmode=0
M$1556 \$1673 RWL[19] RBL[35] GND sg13_lv_nmos L=0.13u W=0.3u AS=0.0525p
+ AD=0.057p PS=0.65u PD=0.68u rfmode=0
M$1557 \$1671 RWL[19] RBL[36] GND sg13_lv_nmos L=0.13u W=0.3u AS=0.0525p
+ AD=0.057p PS=0.65u PD=0.68u rfmode=0
M$1558 \$1669 RWL[19] RBL[37] GND sg13_lv_nmos L=0.13u W=0.3u AS=0.0525p
+ AD=0.057p PS=0.65u PD=0.68u rfmode=0
M$1559 RBL[19] RWL[20] \$1781 GND sg13_lv_nmos L=0.13u W=0.3u AS=0.057p
+ AD=0.0525p PS=0.68u PD=0.65u rfmode=0
M$1560 RBL[20] RWL[20] \$1782 GND sg13_lv_nmos L=0.13u W=0.3u AS=0.057p
+ AD=0.0525p PS=0.68u PD=0.65u rfmode=0
M$1561 RBL[21] RWL[20] \$1784 GND sg13_lv_nmos L=0.13u W=0.3u AS=0.057p
+ AD=0.0525p PS=0.68u PD=0.65u rfmode=0
M$1562 RBL[22] RWL[20] \$1786 GND sg13_lv_nmos L=0.13u W=0.3u AS=0.057p
+ AD=0.0525p PS=0.68u PD=0.65u rfmode=0
M$1563 RBL[23] RWL[20] \$1787 GND sg13_lv_nmos L=0.13u W=0.3u AS=0.057p
+ AD=0.0525p PS=0.68u PD=0.65u rfmode=0
M$1564 RBL[24] RWL[20] \$1785 GND sg13_lv_nmos L=0.13u W=0.3u AS=0.057p
+ AD=0.0525p PS=0.68u PD=0.65u rfmode=0
M$1565 RBL[25] RWL[20] \$1783 GND sg13_lv_nmos L=0.13u W=0.3u AS=0.057p
+ AD=0.0525p PS=0.68u PD=0.65u rfmode=0
M$1566 RBL[26] RWL[20] \$1780 GND sg13_lv_nmos L=0.13u W=0.3u AS=0.057p
+ AD=0.0525p PS=0.68u PD=0.65u rfmode=0
M$1567 RBL[27] RWL[20] \$1779 GND sg13_lv_nmos L=0.13u W=0.3u AS=0.057p
+ AD=0.0525p PS=0.68u PD=0.65u rfmode=0
M$1568 RBL[28] RWL[20] \$1776 GND sg13_lv_nmos L=0.13u W=0.3u AS=0.057p
+ AD=0.0525p PS=0.68u PD=0.65u rfmode=0
M$1569 RBL[29] RWL[20] \$1774 GND sg13_lv_nmos L=0.13u W=0.3u AS=0.057p
+ AD=0.0525p PS=0.68u PD=0.65u rfmode=0
M$1570 RBL[30] RWL[20] \$1771 GND sg13_lv_nmos L=0.13u W=0.3u AS=0.057p
+ AD=0.0525p PS=0.68u PD=0.65u rfmode=0
M$1571 RBL[31] RWL[20] \$1768 GND sg13_lv_nmos L=0.13u W=0.3u AS=0.057p
+ AD=0.0525p PS=0.68u PD=0.65u rfmode=0
M$1572 RBL[32] RWL[20] \$1765 GND sg13_lv_nmos L=0.13u W=0.3u AS=0.057p
+ AD=0.0525p PS=0.68u PD=0.65u rfmode=0
M$1573 RBL[33] RWL[20] \$1763 GND sg13_lv_nmos L=0.13u W=0.3u AS=0.057p
+ AD=0.0525p PS=0.68u PD=0.65u rfmode=0
M$1574 RBL[34] RWL[20] \$1760 GND sg13_lv_nmos L=0.13u W=0.3u AS=0.057p
+ AD=0.0525p PS=0.68u PD=0.65u rfmode=0
M$1575 RBL[35] RWL[20] \$1758 GND sg13_lv_nmos L=0.13u W=0.3u AS=0.057p
+ AD=0.0525p PS=0.68u PD=0.65u rfmode=0
M$1576 RBL[36] RWL[20] \$1756 GND sg13_lv_nmos L=0.13u W=0.3u AS=0.057p
+ AD=0.0525p PS=0.68u PD=0.65u rfmode=0
M$1577 RBL[37] RWL[20] \$1753 GND sg13_lv_nmos L=0.13u W=0.3u AS=0.057p
+ AD=0.0525p PS=0.68u PD=0.65u rfmode=0
M$1578 \$1781 \$1729 GND GND sg13_lv_nmos L=0.13u W=0.3u AS=0.0525p
+ AD=0.331736842105p PS=0.65u PD=2.24315789474u rfmode=0
M$1579 \$1782 \$1730 GND GND sg13_lv_nmos L=0.13u W=0.3u AS=0.0525p
+ AD=0.331736842105p PS=0.65u PD=2.24315789474u rfmode=0
M$1580 \$1784 \$1731 GND GND sg13_lv_nmos L=0.13u W=0.3u AS=0.0525p
+ AD=0.331736842105p PS=0.65u PD=2.24315789474u rfmode=0
M$1581 \$1786 \$1732 GND GND sg13_lv_nmos L=0.13u W=0.3u AS=0.0525p
+ AD=0.331736842105p PS=0.65u PD=2.24315789474u rfmode=0
M$1582 \$1787 \$1733 GND GND sg13_lv_nmos L=0.13u W=0.3u AS=0.0525p
+ AD=0.331736842105p PS=0.65u PD=2.24315789474u rfmode=0
M$1583 \$1785 \$1734 GND GND sg13_lv_nmos L=0.13u W=0.3u AS=0.0525p
+ AD=0.331736842105p PS=0.65u PD=2.24315789474u rfmode=0
M$1584 \$1783 \$1735 GND GND sg13_lv_nmos L=0.13u W=0.3u AS=0.0525p
+ AD=0.331736842105p PS=0.65u PD=2.24315789474u rfmode=0
M$1585 \$1780 \$1736 GND GND sg13_lv_nmos L=0.13u W=0.3u AS=0.0525p
+ AD=0.331736842105p PS=0.65u PD=2.24315789474u rfmode=0
M$1586 \$1779 \$1737 GND GND sg13_lv_nmos L=0.13u W=0.3u AS=0.0525p
+ AD=0.331736842105p PS=0.65u PD=2.24315789474u rfmode=0
M$1587 \$1776 \$1738 GND GND sg13_lv_nmos L=0.13u W=0.3u AS=0.0525p
+ AD=0.331736842105p PS=0.65u PD=2.24315789474u rfmode=0
M$1588 \$1774 \$1739 GND GND sg13_lv_nmos L=0.13u W=0.3u AS=0.0525p
+ AD=0.331736842105p PS=0.65u PD=2.24315789474u rfmode=0
M$1589 \$1771 \$1740 GND GND sg13_lv_nmos L=0.13u W=0.3u AS=0.0525p
+ AD=0.331736842105p PS=0.65u PD=2.24315789474u rfmode=0
M$1590 \$1768 \$1741 GND GND sg13_lv_nmos L=0.13u W=0.3u AS=0.0525p
+ AD=0.331736842105p PS=0.65u PD=2.24315789474u rfmode=0
M$1591 \$1765 \$1742 GND GND sg13_lv_nmos L=0.13u W=0.3u AS=0.0525p
+ AD=0.331736842105p PS=0.65u PD=2.24315789474u rfmode=0
M$1592 \$1763 \$1743 GND GND sg13_lv_nmos L=0.13u W=0.3u AS=0.0525p
+ AD=0.331736842105p PS=0.65u PD=2.24315789474u rfmode=0
M$1593 \$1760 \$1744 GND GND sg13_lv_nmos L=0.13u W=0.3u AS=0.0525p
+ AD=0.331736842105p PS=0.65u PD=2.24315789474u rfmode=0
M$1594 \$1758 \$1745 GND GND sg13_lv_nmos L=0.13u W=0.3u AS=0.0525p
+ AD=0.331736842105p PS=0.65u PD=2.24315789474u rfmode=0
M$1595 \$1756 \$1746 GND GND sg13_lv_nmos L=0.13u W=0.3u AS=0.0525p
+ AD=0.331736842105p PS=0.65u PD=2.24315789474u rfmode=0
M$1596 \$1753 \$1747 GND GND sg13_lv_nmos L=0.13u W=0.3u AS=0.0525p
+ AD=0.331736842105p PS=0.65u PD=2.24315789474u rfmode=0
M$1597 GND \$1788 \$1833 GND sg13_lv_nmos L=0.13u W=0.3u AS=0.331736842105p
+ AD=0.0525p PS=2.24315789474u PD=0.65u rfmode=0
M$1598 GND \$1789 \$1835 GND sg13_lv_nmos L=0.13u W=0.3u AS=0.331736842105p
+ AD=0.0525p PS=2.24315789474u PD=0.65u rfmode=0
M$1599 GND \$1790 \$1837 GND sg13_lv_nmos L=0.13u W=0.3u AS=0.331736842105p
+ AD=0.0525p PS=2.24315789474u PD=0.65u rfmode=0
M$1600 GND \$1791 \$1838 GND sg13_lv_nmos L=0.13u W=0.3u AS=0.331736842105p
+ AD=0.0525p PS=2.24315789474u PD=0.65u rfmode=0
M$1601 GND \$1792 \$1839 GND sg13_lv_nmos L=0.13u W=0.3u AS=0.331736842105p
+ AD=0.0525p PS=2.24315789474u PD=0.65u rfmode=0
M$1602 GND \$1793 \$1841 GND sg13_lv_nmos L=0.13u W=0.3u AS=0.331736842105p
+ AD=0.0525p PS=2.24315789474u PD=0.65u rfmode=0
M$1603 GND \$1794 \$1843 GND sg13_lv_nmos L=0.13u W=0.3u AS=0.331736842105p
+ AD=0.0525p PS=2.24315789474u PD=0.65u rfmode=0
M$1604 GND \$1795 \$1845 GND sg13_lv_nmos L=0.13u W=0.3u AS=0.331736842105p
+ AD=0.0525p PS=2.24315789474u PD=0.65u rfmode=0
M$1605 GND \$1796 \$1846 GND sg13_lv_nmos L=0.13u W=0.3u AS=0.331736842105p
+ AD=0.0525p PS=2.24315789474u PD=0.65u rfmode=0
M$1606 GND \$1797 \$1848 GND sg13_lv_nmos L=0.13u W=0.3u AS=0.331736842105p
+ AD=0.0525p PS=2.24315789474u PD=0.65u rfmode=0
M$1607 GND \$1798 \$1849 GND sg13_lv_nmos L=0.13u W=0.3u AS=0.331736842105p
+ AD=0.0525p PS=2.24315789474u PD=0.65u rfmode=0
M$1608 GND \$1799 \$1851 GND sg13_lv_nmos L=0.13u W=0.3u AS=0.331736842105p
+ AD=0.0525p PS=2.24315789474u PD=0.65u rfmode=0
M$1609 GND \$1800 \$1853 GND sg13_lv_nmos L=0.13u W=0.3u AS=0.331736842105p
+ AD=0.0525p PS=2.24315789474u PD=0.65u rfmode=0
M$1610 GND \$1801 \$1854 GND sg13_lv_nmos L=0.13u W=0.3u AS=0.331736842105p
+ AD=0.0525p PS=2.24315789474u PD=0.65u rfmode=0
M$1611 GND \$1802 \$1856 GND sg13_lv_nmos L=0.13u W=0.3u AS=0.331736842105p
+ AD=0.0525p PS=2.24315789474u PD=0.65u rfmode=0
M$1612 GND \$1803 \$1858 GND sg13_lv_nmos L=0.13u W=0.3u AS=0.331736842105p
+ AD=0.0525p PS=2.24315789474u PD=0.65u rfmode=0
M$1613 GND \$1804 \$1859 GND sg13_lv_nmos L=0.13u W=0.3u AS=0.331736842105p
+ AD=0.0525p PS=2.24315789474u PD=0.65u rfmode=0
M$1614 GND \$1805 \$1861 GND sg13_lv_nmos L=0.13u W=0.3u AS=0.331736842105p
+ AD=0.0525p PS=2.24315789474u PD=0.65u rfmode=0
M$1615 GND \$1806 \$1862 GND sg13_lv_nmos L=0.13u W=0.3u AS=0.331736842105p
+ AD=0.0525p PS=2.24315789474u PD=0.65u rfmode=0
M$1616 \$1833 RWL[21] RBL[0] GND sg13_lv_nmos L=0.13u W=0.3u AS=0.0525p
+ AD=0.057p PS=0.65u PD=0.68u rfmode=0
M$1617 \$1835 RWL[21] RBL[1] GND sg13_lv_nmos L=0.13u W=0.3u AS=0.0525p
+ AD=0.057p PS=0.65u PD=0.68u rfmode=0
M$1618 \$1837 RWL[21] RBL[2] GND sg13_lv_nmos L=0.13u W=0.3u AS=0.0525p
+ AD=0.057p PS=0.65u PD=0.68u rfmode=0
M$1619 \$1838 RWL[21] RBL[3] GND sg13_lv_nmos L=0.13u W=0.3u AS=0.0525p
+ AD=0.057p PS=0.65u PD=0.68u rfmode=0
M$1620 \$1839 RWL[21] RBL[4] GND sg13_lv_nmos L=0.13u W=0.3u AS=0.0525p
+ AD=0.057p PS=0.65u PD=0.68u rfmode=0
M$1621 \$1841 RWL[21] RBL[5] GND sg13_lv_nmos L=0.13u W=0.3u AS=0.0525p
+ AD=0.057p PS=0.65u PD=0.68u rfmode=0
M$1622 \$1843 RWL[21] RBL[6] GND sg13_lv_nmos L=0.13u W=0.3u AS=0.0525p
+ AD=0.057p PS=0.65u PD=0.68u rfmode=0
M$1623 \$1845 RWL[21] RBL[7] GND sg13_lv_nmos L=0.13u W=0.3u AS=0.0525p
+ AD=0.057p PS=0.65u PD=0.68u rfmode=0
M$1624 \$1846 RWL[21] RBL[8] GND sg13_lv_nmos L=0.13u W=0.3u AS=0.0525p
+ AD=0.057p PS=0.65u PD=0.68u rfmode=0
M$1625 \$1848 RWL[21] RBL[9] GND sg13_lv_nmos L=0.13u W=0.3u AS=0.0525p
+ AD=0.057p PS=0.65u PD=0.68u rfmode=0
M$1626 \$1849 RWL[21] RBL[10] GND sg13_lv_nmos L=0.13u W=0.3u AS=0.0525p
+ AD=0.057p PS=0.65u PD=0.68u rfmode=0
M$1627 \$1851 RWL[21] RBL[11] GND sg13_lv_nmos L=0.13u W=0.3u AS=0.0525p
+ AD=0.057p PS=0.65u PD=0.68u rfmode=0
M$1628 \$1853 RWL[21] RBL[12] GND sg13_lv_nmos L=0.13u W=0.3u AS=0.0525p
+ AD=0.057p PS=0.65u PD=0.68u rfmode=0
M$1629 \$1854 RWL[21] RBL[13] GND sg13_lv_nmos L=0.13u W=0.3u AS=0.0525p
+ AD=0.057p PS=0.65u PD=0.68u rfmode=0
M$1630 \$1856 RWL[21] RBL[14] GND sg13_lv_nmos L=0.13u W=0.3u AS=0.0525p
+ AD=0.057p PS=0.65u PD=0.68u rfmode=0
M$1631 \$1858 RWL[21] RBL[15] GND sg13_lv_nmos L=0.13u W=0.3u AS=0.0525p
+ AD=0.057p PS=0.65u PD=0.68u rfmode=0
M$1632 \$1859 RWL[21] RBL[16] GND sg13_lv_nmos L=0.13u W=0.3u AS=0.0525p
+ AD=0.057p PS=0.65u PD=0.68u rfmode=0
M$1633 \$1861 RWL[21] RBL[17] GND sg13_lv_nmos L=0.13u W=0.3u AS=0.0525p
+ AD=0.057p PS=0.65u PD=0.68u rfmode=0
M$1634 \$1862 RWL[21] RBL[18] GND sg13_lv_nmos L=0.13u W=0.3u AS=0.0525p
+ AD=0.057p PS=0.65u PD=0.68u rfmode=0
M$1635 RBL[0] RWL[22] \$1913 GND sg13_lv_nmos L=0.13u W=0.3u AS=0.057p
+ AD=0.0525p PS=0.68u PD=0.65u rfmode=0
M$1636 RBL[1] RWL[22] \$1914 GND sg13_lv_nmos L=0.13u W=0.3u AS=0.057p
+ AD=0.0525p PS=0.68u PD=0.65u rfmode=0
M$1637 RBL[2] RWL[22] \$1915 GND sg13_lv_nmos L=0.13u W=0.3u AS=0.057p
+ AD=0.0525p PS=0.68u PD=0.65u rfmode=0
M$1638 RBL[3] RWL[22] \$1917 GND sg13_lv_nmos L=0.13u W=0.3u AS=0.057p
+ AD=0.0525p PS=0.68u PD=0.65u rfmode=0
M$1639 RBL[4] RWL[22] \$1918 GND sg13_lv_nmos L=0.13u W=0.3u AS=0.057p
+ AD=0.0525p PS=0.68u PD=0.65u rfmode=0
M$1640 RBL[5] RWL[22] \$1920 GND sg13_lv_nmos L=0.13u W=0.3u AS=0.057p
+ AD=0.0525p PS=0.68u PD=0.65u rfmode=0
M$1641 RBL[6] RWL[22] \$1922 GND sg13_lv_nmos L=0.13u W=0.3u AS=0.057p
+ AD=0.0525p PS=0.68u PD=0.65u rfmode=0
M$1642 RBL[7] RWL[22] \$1923 GND sg13_lv_nmos L=0.13u W=0.3u AS=0.057p
+ AD=0.0525p PS=0.68u PD=0.65u rfmode=0
M$1643 RBL[8] RWL[22] \$1925 GND sg13_lv_nmos L=0.13u W=0.3u AS=0.057p
+ AD=0.0525p PS=0.68u PD=0.65u rfmode=0
M$1644 RBL[9] RWL[22] \$1927 GND sg13_lv_nmos L=0.13u W=0.3u AS=0.057p
+ AD=0.0525p PS=0.68u PD=0.65u rfmode=0
M$1645 RBL[10] RWL[22] \$1929 GND sg13_lv_nmos L=0.13u W=0.3u AS=0.057p
+ AD=0.0525p PS=0.68u PD=0.65u rfmode=0
M$1646 RBL[11] RWL[22] \$1930 GND sg13_lv_nmos L=0.13u W=0.3u AS=0.057p
+ AD=0.0525p PS=0.68u PD=0.65u rfmode=0
M$1647 RBL[12] RWL[22] \$1932 GND sg13_lv_nmos L=0.13u W=0.3u AS=0.057p
+ AD=0.0525p PS=0.68u PD=0.65u rfmode=0
M$1648 RBL[13] RWL[22] \$1933 GND sg13_lv_nmos L=0.13u W=0.3u AS=0.057p
+ AD=0.0525p PS=0.68u PD=0.65u rfmode=0
M$1649 RBL[14] RWL[22] \$1935 GND sg13_lv_nmos L=0.13u W=0.3u AS=0.057p
+ AD=0.0525p PS=0.68u PD=0.65u rfmode=0
M$1650 RBL[15] RWL[22] \$1937 GND sg13_lv_nmos L=0.13u W=0.3u AS=0.057p
+ AD=0.0525p PS=0.68u PD=0.65u rfmode=0
M$1651 RBL[16] RWL[22] \$1938 GND sg13_lv_nmos L=0.13u W=0.3u AS=0.057p
+ AD=0.0525p PS=0.68u PD=0.65u rfmode=0
M$1652 RBL[17] RWL[22] \$1940 GND sg13_lv_nmos L=0.13u W=0.3u AS=0.057p
+ AD=0.0525p PS=0.68u PD=0.65u rfmode=0
M$1653 RBL[18] RWL[22] \$1941 GND sg13_lv_nmos L=0.13u W=0.3u AS=0.057p
+ AD=0.0525p PS=0.68u PD=0.65u rfmode=0
M$1654 \$1913 \$1873 GND GND sg13_lv_nmos L=0.13u W=0.3u AS=0.0525p
+ AD=0.331736842105p PS=0.65u PD=2.24315789474u rfmode=0
M$1655 \$1914 \$1874 GND GND sg13_lv_nmos L=0.13u W=0.3u AS=0.0525p
+ AD=0.331736842105p PS=0.65u PD=2.24315789474u rfmode=0
M$1656 \$1915 \$1875 GND GND sg13_lv_nmos L=0.13u W=0.3u AS=0.0525p
+ AD=0.331736842105p PS=0.65u PD=2.24315789474u rfmode=0
M$1657 \$1917 \$1876 GND GND sg13_lv_nmos L=0.13u W=0.3u AS=0.0525p
+ AD=0.331736842105p PS=0.65u PD=2.24315789474u rfmode=0
M$1658 \$1918 \$1877 GND GND sg13_lv_nmos L=0.13u W=0.3u AS=0.0525p
+ AD=0.331736842105p PS=0.65u PD=2.24315789474u rfmode=0
M$1659 \$1920 \$1878 GND GND sg13_lv_nmos L=0.13u W=0.3u AS=0.0525p
+ AD=0.331736842105p PS=0.65u PD=2.24315789474u rfmode=0
M$1660 \$1922 \$1879 GND GND sg13_lv_nmos L=0.13u W=0.3u AS=0.0525p
+ AD=0.331736842105p PS=0.65u PD=2.24315789474u rfmode=0
M$1661 \$1923 \$1880 GND GND sg13_lv_nmos L=0.13u W=0.3u AS=0.0525p
+ AD=0.331736842105p PS=0.65u PD=2.24315789474u rfmode=0
M$1662 \$1925 \$1881 GND GND sg13_lv_nmos L=0.13u W=0.3u AS=0.0525p
+ AD=0.331736842105p PS=0.65u PD=2.24315789474u rfmode=0
M$1663 \$1927 \$1882 GND GND sg13_lv_nmos L=0.13u W=0.3u AS=0.0525p
+ AD=0.331736842105p PS=0.65u PD=2.24315789474u rfmode=0
M$1664 \$1929 \$1883 GND GND sg13_lv_nmos L=0.13u W=0.3u AS=0.0525p
+ AD=0.331736842105p PS=0.65u PD=2.24315789474u rfmode=0
M$1665 \$1930 \$1884 GND GND sg13_lv_nmos L=0.13u W=0.3u AS=0.0525p
+ AD=0.331736842105p PS=0.65u PD=2.24315789474u rfmode=0
M$1666 \$1932 \$1885 GND GND sg13_lv_nmos L=0.13u W=0.3u AS=0.0525p
+ AD=0.331736842105p PS=0.65u PD=2.24315789474u rfmode=0
M$1667 \$1933 \$1886 GND GND sg13_lv_nmos L=0.13u W=0.3u AS=0.0525p
+ AD=0.331736842105p PS=0.65u PD=2.24315789474u rfmode=0
M$1668 \$1935 \$1887 GND GND sg13_lv_nmos L=0.13u W=0.3u AS=0.0525p
+ AD=0.331736842105p PS=0.65u PD=2.24315789474u rfmode=0
M$1669 \$1937 \$1888 GND GND sg13_lv_nmos L=0.13u W=0.3u AS=0.0525p
+ AD=0.331736842105p PS=0.65u PD=2.24315789474u rfmode=0
M$1670 \$1938 \$1889 GND GND sg13_lv_nmos L=0.13u W=0.3u AS=0.0525p
+ AD=0.331736842105p PS=0.65u PD=2.24315789474u rfmode=0
M$1671 \$1940 \$1890 GND GND sg13_lv_nmos L=0.13u W=0.3u AS=0.0525p
+ AD=0.331736842105p PS=0.65u PD=2.24315789474u rfmode=0
M$1672 \$1941 \$1891 GND GND sg13_lv_nmos L=0.13u W=0.3u AS=0.0525p
+ AD=0.331736842105p PS=0.65u PD=2.24315789474u rfmode=0
M$1673 GND \$1807 \$1864 GND sg13_lv_nmos L=0.13u W=0.3u AS=0.331736842105p
+ AD=0.0525p PS=2.24315789474u PD=0.65u rfmode=0
M$1674 GND \$1808 \$1866 GND sg13_lv_nmos L=0.13u W=0.3u AS=0.331736842105p
+ AD=0.0525p PS=2.24315789474u PD=0.65u rfmode=0
M$1675 GND \$1809 \$1868 GND sg13_lv_nmos L=0.13u W=0.3u AS=0.331736842105p
+ AD=0.0525p PS=2.24315789474u PD=0.65u rfmode=0
M$1676 GND \$1810 \$1869 GND sg13_lv_nmos L=0.13u W=0.3u AS=0.331736842105p
+ AD=0.0525p PS=2.24315789474u PD=0.65u rfmode=0
M$1677 GND \$1811 \$1867 GND sg13_lv_nmos L=0.13u W=0.3u AS=0.331736842105p
+ AD=0.0525p PS=2.24315789474u PD=0.65u rfmode=0
M$1678 GND \$1812 \$1865 GND sg13_lv_nmos L=0.13u W=0.3u AS=0.331736842105p
+ AD=0.0525p PS=2.24315789474u PD=0.65u rfmode=0
M$1679 GND \$1813 \$1863 GND sg13_lv_nmos L=0.13u W=0.3u AS=0.331736842105p
+ AD=0.0525p PS=2.24315789474u PD=0.65u rfmode=0
M$1680 GND \$1814 \$1860 GND sg13_lv_nmos L=0.13u W=0.3u AS=0.331736842105p
+ AD=0.0525p PS=2.24315789474u PD=0.65u rfmode=0
M$1681 GND \$1815 \$1857 GND sg13_lv_nmos L=0.13u W=0.3u AS=0.331736842105p
+ AD=0.0525p PS=2.24315789474u PD=0.65u rfmode=0
M$1682 GND \$1816 \$1855 GND sg13_lv_nmos L=0.13u W=0.3u AS=0.331736842105p
+ AD=0.0525p PS=2.24315789474u PD=0.65u rfmode=0
M$1683 GND \$1817 \$1852 GND sg13_lv_nmos L=0.13u W=0.3u AS=0.331736842105p
+ AD=0.0525p PS=2.24315789474u PD=0.65u rfmode=0
M$1684 GND \$1818 \$1850 GND sg13_lv_nmos L=0.13u W=0.3u AS=0.331736842105p
+ AD=0.0525p PS=2.24315789474u PD=0.65u rfmode=0
M$1685 GND \$1819 \$1847 GND sg13_lv_nmos L=0.13u W=0.3u AS=0.331736842105p
+ AD=0.0525p PS=2.24315789474u PD=0.65u rfmode=0
M$1686 GND \$1820 \$1844 GND sg13_lv_nmos L=0.13u W=0.3u AS=0.331736842105p
+ AD=0.0525p PS=2.24315789474u PD=0.65u rfmode=0
M$1687 GND \$1821 \$1842 GND sg13_lv_nmos L=0.13u W=0.3u AS=0.331736842105p
+ AD=0.0525p PS=2.24315789474u PD=0.65u rfmode=0
M$1688 GND \$1822 \$1840 GND sg13_lv_nmos L=0.13u W=0.3u AS=0.331736842105p
+ AD=0.0525p PS=2.24315789474u PD=0.65u rfmode=0
M$1689 GND \$1823 \$1836 GND sg13_lv_nmos L=0.13u W=0.3u AS=0.331736842105p
+ AD=0.0525p PS=2.24315789474u PD=0.65u rfmode=0
M$1690 GND \$1824 \$1834 GND sg13_lv_nmos L=0.13u W=0.3u AS=0.331736842105p
+ AD=0.0525p PS=2.24315789474u PD=0.65u rfmode=0
M$1691 GND \$1825 \$1832 GND sg13_lv_nmos L=0.13u W=0.3u AS=0.331736842105p
+ AD=0.0525p PS=2.24315789474u PD=0.65u rfmode=0
M$1692 \$1864 RWL[21] RBL[19] GND sg13_lv_nmos L=0.13u W=0.3u AS=0.0525p
+ AD=0.057p PS=0.65u PD=0.68u rfmode=0
M$1693 \$1866 RWL[21] RBL[20] GND sg13_lv_nmos L=0.13u W=0.3u AS=0.0525p
+ AD=0.057p PS=0.65u PD=0.68u rfmode=0
M$1694 \$1868 RWL[21] RBL[21] GND sg13_lv_nmos L=0.13u W=0.3u AS=0.0525p
+ AD=0.057p PS=0.65u PD=0.68u rfmode=0
M$1695 \$1869 RWL[21] RBL[22] GND sg13_lv_nmos L=0.13u W=0.3u AS=0.0525p
+ AD=0.057p PS=0.65u PD=0.68u rfmode=0
M$1696 \$1867 RWL[21] RBL[23] GND sg13_lv_nmos L=0.13u W=0.3u AS=0.0525p
+ AD=0.057p PS=0.65u PD=0.68u rfmode=0
M$1697 \$1865 RWL[21] RBL[24] GND sg13_lv_nmos L=0.13u W=0.3u AS=0.0525p
+ AD=0.057p PS=0.65u PD=0.68u rfmode=0
M$1698 \$1863 RWL[21] RBL[25] GND sg13_lv_nmos L=0.13u W=0.3u AS=0.0525p
+ AD=0.057p PS=0.65u PD=0.68u rfmode=0
M$1699 \$1860 RWL[21] RBL[26] GND sg13_lv_nmos L=0.13u W=0.3u AS=0.0525p
+ AD=0.057p PS=0.65u PD=0.68u rfmode=0
M$1700 \$1857 RWL[21] RBL[27] GND sg13_lv_nmos L=0.13u W=0.3u AS=0.0525p
+ AD=0.057p PS=0.65u PD=0.68u rfmode=0
M$1701 \$1855 RWL[21] RBL[28] GND sg13_lv_nmos L=0.13u W=0.3u AS=0.0525p
+ AD=0.057p PS=0.65u PD=0.68u rfmode=0
M$1702 \$1852 RWL[21] RBL[29] GND sg13_lv_nmos L=0.13u W=0.3u AS=0.0525p
+ AD=0.057p PS=0.65u PD=0.68u rfmode=0
M$1703 \$1850 RWL[21] RBL[30] GND sg13_lv_nmos L=0.13u W=0.3u AS=0.0525p
+ AD=0.057p PS=0.65u PD=0.68u rfmode=0
M$1704 \$1847 RWL[21] RBL[31] GND sg13_lv_nmos L=0.13u W=0.3u AS=0.0525p
+ AD=0.057p PS=0.65u PD=0.68u rfmode=0
M$1705 \$1844 RWL[21] RBL[32] GND sg13_lv_nmos L=0.13u W=0.3u AS=0.0525p
+ AD=0.057p PS=0.65u PD=0.68u rfmode=0
M$1706 \$1842 RWL[21] RBL[33] GND sg13_lv_nmos L=0.13u W=0.3u AS=0.0525p
+ AD=0.057p PS=0.65u PD=0.68u rfmode=0
M$1707 \$1840 RWL[21] RBL[34] GND sg13_lv_nmos L=0.13u W=0.3u AS=0.0525p
+ AD=0.057p PS=0.65u PD=0.68u rfmode=0
M$1708 \$1836 RWL[21] RBL[35] GND sg13_lv_nmos L=0.13u W=0.3u AS=0.0525p
+ AD=0.057p PS=0.65u PD=0.68u rfmode=0
M$1709 \$1834 RWL[21] RBL[36] GND sg13_lv_nmos L=0.13u W=0.3u AS=0.0525p
+ AD=0.057p PS=0.65u PD=0.68u rfmode=0
M$1710 \$1832 RWL[21] RBL[37] GND sg13_lv_nmos L=0.13u W=0.3u AS=0.0525p
+ AD=0.057p PS=0.65u PD=0.68u rfmode=0
M$1711 RBL[19] RWL[22] \$1944 GND sg13_lv_nmos L=0.13u W=0.3u AS=0.057p
+ AD=0.0525p PS=0.68u PD=0.65u rfmode=0
M$1712 RBL[20] RWL[22] \$1945 GND sg13_lv_nmos L=0.13u W=0.3u AS=0.057p
+ AD=0.0525p PS=0.68u PD=0.65u rfmode=0
M$1713 RBL[21] RWL[22] \$1947 GND sg13_lv_nmos L=0.13u W=0.3u AS=0.057p
+ AD=0.0525p PS=0.68u PD=0.65u rfmode=0
M$1714 RBL[22] RWL[22] \$1949 GND sg13_lv_nmos L=0.13u W=0.3u AS=0.057p
+ AD=0.0525p PS=0.68u PD=0.65u rfmode=0
M$1715 RBL[23] RWL[22] \$1950 GND sg13_lv_nmos L=0.13u W=0.3u AS=0.057p
+ AD=0.0525p PS=0.68u PD=0.65u rfmode=0
M$1716 RBL[24] RWL[22] \$1948 GND sg13_lv_nmos L=0.13u W=0.3u AS=0.057p
+ AD=0.0525p PS=0.68u PD=0.65u rfmode=0
M$1717 RBL[25] RWL[22] \$1946 GND sg13_lv_nmos L=0.13u W=0.3u AS=0.057p
+ AD=0.0525p PS=0.68u PD=0.65u rfmode=0
M$1718 RBL[26] RWL[22] \$1943 GND sg13_lv_nmos L=0.13u W=0.3u AS=0.057p
+ AD=0.0525p PS=0.68u PD=0.65u rfmode=0
M$1719 RBL[27] RWL[22] \$1942 GND sg13_lv_nmos L=0.13u W=0.3u AS=0.057p
+ AD=0.0525p PS=0.68u PD=0.65u rfmode=0
M$1720 RBL[28] RWL[22] \$1939 GND sg13_lv_nmos L=0.13u W=0.3u AS=0.057p
+ AD=0.0525p PS=0.68u PD=0.65u rfmode=0
M$1721 RBL[29] RWL[22] \$1936 GND sg13_lv_nmos L=0.13u W=0.3u AS=0.057p
+ AD=0.0525p PS=0.68u PD=0.65u rfmode=0
M$1722 RBL[30] RWL[22] \$1934 GND sg13_lv_nmos L=0.13u W=0.3u AS=0.057p
+ AD=0.0525p PS=0.68u PD=0.65u rfmode=0
M$1723 RBL[31] RWL[22] \$1931 GND sg13_lv_nmos L=0.13u W=0.3u AS=0.057p
+ AD=0.0525p PS=0.68u PD=0.65u rfmode=0
M$1724 RBL[32] RWL[22] \$1928 GND sg13_lv_nmos L=0.13u W=0.3u AS=0.057p
+ AD=0.0525p PS=0.68u PD=0.65u rfmode=0
M$1725 RBL[33] RWL[22] \$1926 GND sg13_lv_nmos L=0.13u W=0.3u AS=0.057p
+ AD=0.0525p PS=0.68u PD=0.65u rfmode=0
M$1726 RBL[34] RWL[22] \$1924 GND sg13_lv_nmos L=0.13u W=0.3u AS=0.057p
+ AD=0.0525p PS=0.68u PD=0.65u rfmode=0
M$1727 RBL[35] RWL[22] \$1921 GND sg13_lv_nmos L=0.13u W=0.3u AS=0.057p
+ AD=0.0525p PS=0.68u PD=0.65u rfmode=0
M$1728 RBL[36] RWL[22] \$1919 GND sg13_lv_nmos L=0.13u W=0.3u AS=0.057p
+ AD=0.0525p PS=0.68u PD=0.65u rfmode=0
M$1729 RBL[37] RWL[22] \$1916 GND sg13_lv_nmos L=0.13u W=0.3u AS=0.057p
+ AD=0.0525p PS=0.68u PD=0.65u rfmode=0
M$1730 \$1944 \$1892 GND GND sg13_lv_nmos L=0.13u W=0.3u AS=0.0525p
+ AD=0.331736842105p PS=0.65u PD=2.24315789474u rfmode=0
M$1731 \$1945 \$1893 GND GND sg13_lv_nmos L=0.13u W=0.3u AS=0.0525p
+ AD=0.331736842105p PS=0.65u PD=2.24315789474u rfmode=0
M$1732 \$1947 \$1894 GND GND sg13_lv_nmos L=0.13u W=0.3u AS=0.0525p
+ AD=0.331736842105p PS=0.65u PD=2.24315789474u rfmode=0
M$1733 \$1949 \$1895 GND GND sg13_lv_nmos L=0.13u W=0.3u AS=0.0525p
+ AD=0.331736842105p PS=0.65u PD=2.24315789474u rfmode=0
M$1734 \$1950 \$1896 GND GND sg13_lv_nmos L=0.13u W=0.3u AS=0.0525p
+ AD=0.331736842105p PS=0.65u PD=2.24315789474u rfmode=0
M$1735 \$1948 \$1897 GND GND sg13_lv_nmos L=0.13u W=0.3u AS=0.0525p
+ AD=0.331736842105p PS=0.65u PD=2.24315789474u rfmode=0
M$1736 \$1946 \$1898 GND GND sg13_lv_nmos L=0.13u W=0.3u AS=0.0525p
+ AD=0.331736842105p PS=0.65u PD=2.24315789474u rfmode=0
M$1737 \$1943 \$1899 GND GND sg13_lv_nmos L=0.13u W=0.3u AS=0.0525p
+ AD=0.331736842105p PS=0.65u PD=2.24315789474u rfmode=0
M$1738 \$1942 \$1900 GND GND sg13_lv_nmos L=0.13u W=0.3u AS=0.0525p
+ AD=0.331736842105p PS=0.65u PD=2.24315789474u rfmode=0
M$1739 \$1939 \$1901 GND GND sg13_lv_nmos L=0.13u W=0.3u AS=0.0525p
+ AD=0.331736842105p PS=0.65u PD=2.24315789474u rfmode=0
M$1740 \$1936 \$1902 GND GND sg13_lv_nmos L=0.13u W=0.3u AS=0.0525p
+ AD=0.331736842105p PS=0.65u PD=2.24315789474u rfmode=0
M$1741 \$1934 \$1903 GND GND sg13_lv_nmos L=0.13u W=0.3u AS=0.0525p
+ AD=0.331736842105p PS=0.65u PD=2.24315789474u rfmode=0
M$1742 \$1931 \$1904 GND GND sg13_lv_nmos L=0.13u W=0.3u AS=0.0525p
+ AD=0.331736842105p PS=0.65u PD=2.24315789474u rfmode=0
M$1743 \$1928 \$1905 GND GND sg13_lv_nmos L=0.13u W=0.3u AS=0.0525p
+ AD=0.331736842105p PS=0.65u PD=2.24315789474u rfmode=0
M$1744 \$1926 \$1906 GND GND sg13_lv_nmos L=0.13u W=0.3u AS=0.0525p
+ AD=0.331736842105p PS=0.65u PD=2.24315789474u rfmode=0
M$1745 \$1924 \$1907 GND GND sg13_lv_nmos L=0.13u W=0.3u AS=0.0525p
+ AD=0.331736842105p PS=0.65u PD=2.24315789474u rfmode=0
M$1746 \$1921 \$1908 GND GND sg13_lv_nmos L=0.13u W=0.3u AS=0.0525p
+ AD=0.331736842105p PS=0.65u PD=2.24315789474u rfmode=0
M$1747 \$1919 \$1909 GND GND sg13_lv_nmos L=0.13u W=0.3u AS=0.0525p
+ AD=0.331736842105p PS=0.65u PD=2.24315789474u rfmode=0
M$1748 \$1916 \$1910 GND GND sg13_lv_nmos L=0.13u W=0.3u AS=0.0525p
+ AD=0.331736842105p PS=0.65u PD=2.24315789474u rfmode=0
M$1749 GND \$1951 \$1996 GND sg13_lv_nmos L=0.13u W=0.3u AS=0.331736842105p
+ AD=0.0525p PS=2.24315789474u PD=0.65u rfmode=0
M$1750 GND \$1952 \$1998 GND sg13_lv_nmos L=0.13u W=0.3u AS=0.331736842105p
+ AD=0.0525p PS=2.24315789474u PD=0.65u rfmode=0
M$1751 GND \$1953 \$2000 GND sg13_lv_nmos L=0.13u W=0.3u AS=0.331736842105p
+ AD=0.0525p PS=2.24315789474u PD=0.65u rfmode=0
M$1752 GND \$1954 \$2001 GND sg13_lv_nmos L=0.13u W=0.3u AS=0.331736842105p
+ AD=0.0525p PS=2.24315789474u PD=0.65u rfmode=0
M$1753 GND \$1955 \$2003 GND sg13_lv_nmos L=0.13u W=0.3u AS=0.331736842105p
+ AD=0.0525p PS=2.24315789474u PD=0.65u rfmode=0
M$1754 GND \$1956 \$2004 GND sg13_lv_nmos L=0.13u W=0.3u AS=0.331736842105p
+ AD=0.0525p PS=2.24315789474u PD=0.65u rfmode=0
M$1755 GND \$1957 \$2006 GND sg13_lv_nmos L=0.13u W=0.3u AS=0.331736842105p
+ AD=0.0525p PS=2.24315789474u PD=0.65u rfmode=0
M$1756 GND \$1958 \$2008 GND sg13_lv_nmos L=0.13u W=0.3u AS=0.331736842105p
+ AD=0.0525p PS=2.24315789474u PD=0.65u rfmode=0
M$1757 GND \$1959 \$2009 GND sg13_lv_nmos L=0.13u W=0.3u AS=0.331736842105p
+ AD=0.0525p PS=2.24315789474u PD=0.65u rfmode=0
M$1758 GND \$1960 \$2011 GND sg13_lv_nmos L=0.13u W=0.3u AS=0.331736842105p
+ AD=0.0525p PS=2.24315789474u PD=0.65u rfmode=0
M$1759 GND \$1961 \$2012 GND sg13_lv_nmos L=0.13u W=0.3u AS=0.331736842105p
+ AD=0.0525p PS=2.24315789474u PD=0.65u rfmode=0
M$1760 GND \$1962 \$2014 GND sg13_lv_nmos L=0.13u W=0.3u AS=0.331736842105p
+ AD=0.0525p PS=2.24315789474u PD=0.65u rfmode=0
M$1761 GND \$1963 \$2016 GND sg13_lv_nmos L=0.13u W=0.3u AS=0.331736842105p
+ AD=0.0525p PS=2.24315789474u PD=0.65u rfmode=0
M$1762 GND \$1964 \$2017 GND sg13_lv_nmos L=0.13u W=0.3u AS=0.331736842105p
+ AD=0.0525p PS=2.24315789474u PD=0.65u rfmode=0
M$1763 GND \$1965 \$2019 GND sg13_lv_nmos L=0.13u W=0.3u AS=0.331736842105p
+ AD=0.0525p PS=2.24315789474u PD=0.65u rfmode=0
M$1764 GND \$1966 \$2020 GND sg13_lv_nmos L=0.13u W=0.3u AS=0.331736842105p
+ AD=0.0525p PS=2.24315789474u PD=0.65u rfmode=0
M$1765 GND \$1967 \$2022 GND sg13_lv_nmos L=0.13u W=0.3u AS=0.331736842105p
+ AD=0.0525p PS=2.24315789474u PD=0.65u rfmode=0
M$1766 GND \$1968 \$2024 GND sg13_lv_nmos L=0.13u W=0.3u AS=0.331736842105p
+ AD=0.0525p PS=2.24315789474u PD=0.65u rfmode=0
M$1767 GND \$1969 \$2025 GND sg13_lv_nmos L=0.13u W=0.3u AS=0.331736842105p
+ AD=0.0525p PS=2.24315789474u PD=0.65u rfmode=0
M$1768 \$1996 RWL[23] RBL[0] GND sg13_lv_nmos L=0.13u W=0.3u AS=0.0525p
+ AD=0.057p PS=0.65u PD=0.68u rfmode=0
M$1769 \$1998 RWL[23] RBL[1] GND sg13_lv_nmos L=0.13u W=0.3u AS=0.0525p
+ AD=0.057p PS=0.65u PD=0.68u rfmode=0
M$1770 \$2000 RWL[23] RBL[2] GND sg13_lv_nmos L=0.13u W=0.3u AS=0.0525p
+ AD=0.057p PS=0.65u PD=0.68u rfmode=0
M$1771 \$2001 RWL[23] RBL[3] GND sg13_lv_nmos L=0.13u W=0.3u AS=0.0525p
+ AD=0.057p PS=0.65u PD=0.68u rfmode=0
M$1772 \$2003 RWL[23] RBL[4] GND sg13_lv_nmos L=0.13u W=0.3u AS=0.0525p
+ AD=0.057p PS=0.65u PD=0.68u rfmode=0
M$1773 \$2004 RWL[23] RBL[5] GND sg13_lv_nmos L=0.13u W=0.3u AS=0.0525p
+ AD=0.057p PS=0.65u PD=0.68u rfmode=0
M$1774 \$2006 RWL[23] RBL[6] GND sg13_lv_nmos L=0.13u W=0.3u AS=0.0525p
+ AD=0.057p PS=0.65u PD=0.68u rfmode=0
M$1775 \$2008 RWL[23] RBL[7] GND sg13_lv_nmos L=0.13u W=0.3u AS=0.0525p
+ AD=0.057p PS=0.65u PD=0.68u rfmode=0
M$1776 \$2009 RWL[23] RBL[8] GND sg13_lv_nmos L=0.13u W=0.3u AS=0.0525p
+ AD=0.057p PS=0.65u PD=0.68u rfmode=0
M$1777 \$2011 RWL[23] RBL[9] GND sg13_lv_nmos L=0.13u W=0.3u AS=0.0525p
+ AD=0.057p PS=0.65u PD=0.68u rfmode=0
M$1778 \$2012 RWL[23] RBL[10] GND sg13_lv_nmos L=0.13u W=0.3u AS=0.0525p
+ AD=0.057p PS=0.65u PD=0.68u rfmode=0
M$1779 \$2014 RWL[23] RBL[11] GND sg13_lv_nmos L=0.13u W=0.3u AS=0.0525p
+ AD=0.057p PS=0.65u PD=0.68u rfmode=0
M$1780 \$2016 RWL[23] RBL[12] GND sg13_lv_nmos L=0.13u W=0.3u AS=0.0525p
+ AD=0.057p PS=0.65u PD=0.68u rfmode=0
M$1781 \$2017 RWL[23] RBL[13] GND sg13_lv_nmos L=0.13u W=0.3u AS=0.0525p
+ AD=0.057p PS=0.65u PD=0.68u rfmode=0
M$1782 \$2019 RWL[23] RBL[14] GND sg13_lv_nmos L=0.13u W=0.3u AS=0.0525p
+ AD=0.057p PS=0.65u PD=0.68u rfmode=0
M$1783 \$2020 RWL[23] RBL[15] GND sg13_lv_nmos L=0.13u W=0.3u AS=0.0525p
+ AD=0.057p PS=0.65u PD=0.68u rfmode=0
M$1784 \$2022 RWL[23] RBL[16] GND sg13_lv_nmos L=0.13u W=0.3u AS=0.0525p
+ AD=0.057p PS=0.65u PD=0.68u rfmode=0
M$1785 \$2024 RWL[23] RBL[17] GND sg13_lv_nmos L=0.13u W=0.3u AS=0.0525p
+ AD=0.057p PS=0.65u PD=0.68u rfmode=0
M$1786 \$2025 RWL[23] RBL[18] GND sg13_lv_nmos L=0.13u W=0.3u AS=0.0525p
+ AD=0.057p PS=0.65u PD=0.68u rfmode=0
M$1787 RBL[0] RWL[24] \$2076 GND sg13_lv_nmos L=0.13u W=0.3u AS=0.057p
+ AD=0.0525p PS=0.68u PD=0.65u rfmode=0
M$1788 RBL[1] RWL[24] \$2077 GND sg13_lv_nmos L=0.13u W=0.3u AS=0.057p
+ AD=0.0525p PS=0.68u PD=0.65u rfmode=0
M$1789 RBL[2] RWL[24] \$2078 GND sg13_lv_nmos L=0.13u W=0.3u AS=0.057p
+ AD=0.0525p PS=0.68u PD=0.65u rfmode=0
M$1790 RBL[3] RWL[24] \$2080 GND sg13_lv_nmos L=0.13u W=0.3u AS=0.057p
+ AD=0.0525p PS=0.68u PD=0.65u rfmode=0
M$1791 RBL[4] RWL[24] \$2081 GND sg13_lv_nmos L=0.13u W=0.3u AS=0.057p
+ AD=0.0525p PS=0.68u PD=0.65u rfmode=0
M$1792 RBL[5] RWL[24] \$2083 GND sg13_lv_nmos L=0.13u W=0.3u AS=0.057p
+ AD=0.0525p PS=0.68u PD=0.65u rfmode=0
M$1793 RBL[6] RWL[24] \$2085 GND sg13_lv_nmos L=0.13u W=0.3u AS=0.057p
+ AD=0.0525p PS=0.68u PD=0.65u rfmode=0
M$1794 RBL[7] RWL[24] \$2086 GND sg13_lv_nmos L=0.13u W=0.3u AS=0.057p
+ AD=0.0525p PS=0.68u PD=0.65u rfmode=0
M$1795 RBL[8] RWL[24] \$2088 GND sg13_lv_nmos L=0.13u W=0.3u AS=0.057p
+ AD=0.0525p PS=0.68u PD=0.65u rfmode=0
M$1796 RBL[9] RWL[24] \$2090 GND sg13_lv_nmos L=0.13u W=0.3u AS=0.057p
+ AD=0.0525p PS=0.68u PD=0.65u rfmode=0
M$1797 RBL[10] RWL[24] \$2091 GND sg13_lv_nmos L=0.13u W=0.3u AS=0.057p
+ AD=0.0525p PS=0.68u PD=0.65u rfmode=0
M$1798 RBL[11] RWL[24] \$2093 GND sg13_lv_nmos L=0.13u W=0.3u AS=0.057p
+ AD=0.0525p PS=0.68u PD=0.65u rfmode=0
M$1799 RBL[12] RWL[24] \$2095 GND sg13_lv_nmos L=0.13u W=0.3u AS=0.057p
+ AD=0.0525p PS=0.68u PD=0.65u rfmode=0
M$1800 RBL[13] RWL[24] \$2096 GND sg13_lv_nmos L=0.13u W=0.3u AS=0.057p
+ AD=0.0525p PS=0.68u PD=0.65u rfmode=0
M$1801 RBL[14] RWL[24] \$2098 GND sg13_lv_nmos L=0.13u W=0.3u AS=0.057p
+ AD=0.0525p PS=0.68u PD=0.65u rfmode=0
M$1802 RBL[15] RWL[24] \$2099 GND sg13_lv_nmos L=0.13u W=0.3u AS=0.057p
+ AD=0.0525p PS=0.68u PD=0.65u rfmode=0
M$1803 RBL[16] RWL[24] \$2101 GND sg13_lv_nmos L=0.13u W=0.3u AS=0.057p
+ AD=0.0525p PS=0.68u PD=0.65u rfmode=0
M$1804 RBL[17] RWL[24] \$2103 GND sg13_lv_nmos L=0.13u W=0.3u AS=0.057p
+ AD=0.0525p PS=0.68u PD=0.65u rfmode=0
M$1805 RBL[18] RWL[24] \$2104 GND sg13_lv_nmos L=0.13u W=0.3u AS=0.057p
+ AD=0.0525p PS=0.68u PD=0.65u rfmode=0
M$1806 \$2076 \$2036 GND GND sg13_lv_nmos L=0.13u W=0.3u AS=0.0525p
+ AD=0.331736842105p PS=0.65u PD=2.24315789474u rfmode=0
M$1807 \$2077 \$2037 GND GND sg13_lv_nmos L=0.13u W=0.3u AS=0.0525p
+ AD=0.331736842105p PS=0.65u PD=2.24315789474u rfmode=0
M$1808 \$2078 \$2038 GND GND sg13_lv_nmos L=0.13u W=0.3u AS=0.0525p
+ AD=0.331736842105p PS=0.65u PD=2.24315789474u rfmode=0
M$1809 \$2080 \$2039 GND GND sg13_lv_nmos L=0.13u W=0.3u AS=0.0525p
+ AD=0.331736842105p PS=0.65u PD=2.24315789474u rfmode=0
M$1810 \$2081 \$2040 GND GND sg13_lv_nmos L=0.13u W=0.3u AS=0.0525p
+ AD=0.331736842105p PS=0.65u PD=2.24315789474u rfmode=0
M$1811 \$2083 \$2041 GND GND sg13_lv_nmos L=0.13u W=0.3u AS=0.0525p
+ AD=0.331736842105p PS=0.65u PD=2.24315789474u rfmode=0
M$1812 \$2085 \$2042 GND GND sg13_lv_nmos L=0.13u W=0.3u AS=0.0525p
+ AD=0.331736842105p PS=0.65u PD=2.24315789474u rfmode=0
M$1813 \$2086 \$2043 GND GND sg13_lv_nmos L=0.13u W=0.3u AS=0.0525p
+ AD=0.331736842105p PS=0.65u PD=2.24315789474u rfmode=0
M$1814 \$2088 \$2044 GND GND sg13_lv_nmos L=0.13u W=0.3u AS=0.0525p
+ AD=0.331736842105p PS=0.65u PD=2.24315789474u rfmode=0
M$1815 \$2090 \$2045 GND GND sg13_lv_nmos L=0.13u W=0.3u AS=0.0525p
+ AD=0.331736842105p PS=0.65u PD=2.24315789474u rfmode=0
M$1816 \$2091 \$2046 GND GND sg13_lv_nmos L=0.13u W=0.3u AS=0.0525p
+ AD=0.331736842105p PS=0.65u PD=2.24315789474u rfmode=0
M$1817 \$2093 \$2047 GND GND sg13_lv_nmos L=0.13u W=0.3u AS=0.0525p
+ AD=0.331736842105p PS=0.65u PD=2.24315789474u rfmode=0
M$1818 \$2095 \$2048 GND GND sg13_lv_nmos L=0.13u W=0.3u AS=0.0525p
+ AD=0.331736842105p PS=0.65u PD=2.24315789474u rfmode=0
M$1819 \$2096 \$2049 GND GND sg13_lv_nmos L=0.13u W=0.3u AS=0.0525p
+ AD=0.331736842105p PS=0.65u PD=2.24315789474u rfmode=0
M$1820 \$2098 \$2050 GND GND sg13_lv_nmos L=0.13u W=0.3u AS=0.0525p
+ AD=0.331736842105p PS=0.65u PD=2.24315789474u rfmode=0
M$1821 \$2099 \$2051 GND GND sg13_lv_nmos L=0.13u W=0.3u AS=0.0525p
+ AD=0.331736842105p PS=0.65u PD=2.24315789474u rfmode=0
M$1822 \$2101 \$2052 GND GND sg13_lv_nmos L=0.13u W=0.3u AS=0.0525p
+ AD=0.331736842105p PS=0.65u PD=2.24315789474u rfmode=0
M$1823 \$2103 \$2053 GND GND sg13_lv_nmos L=0.13u W=0.3u AS=0.0525p
+ AD=0.331736842105p PS=0.65u PD=2.24315789474u rfmode=0
M$1824 \$2104 \$2054 GND GND sg13_lv_nmos L=0.13u W=0.3u AS=0.0525p
+ AD=0.331736842105p PS=0.65u PD=2.24315789474u rfmode=0
M$1825 GND \$1970 \$2028 GND sg13_lv_nmos L=0.13u W=0.3u AS=0.331736842105p
+ AD=0.0525p PS=2.24315789474u PD=0.65u rfmode=0
M$1826 GND \$1971 \$2029 GND sg13_lv_nmos L=0.13u W=0.3u AS=0.331736842105p
+ AD=0.0525p PS=2.24315789474u PD=0.65u rfmode=0
M$1827 GND \$1972 \$2031 GND sg13_lv_nmos L=0.13u W=0.3u AS=0.331736842105p
+ AD=0.0525p PS=2.24315789474u PD=0.65u rfmode=0
M$1828 GND \$1973 \$2032 GND sg13_lv_nmos L=0.13u W=0.3u AS=0.331736842105p
+ AD=0.0525p PS=2.24315789474u PD=0.65u rfmode=0
M$1829 GND \$1974 \$2030 GND sg13_lv_nmos L=0.13u W=0.3u AS=0.331736842105p
+ AD=0.0525p PS=2.24315789474u PD=0.65u rfmode=0
M$1830 GND \$1975 \$2027 GND sg13_lv_nmos L=0.13u W=0.3u AS=0.331736842105p
+ AD=0.0525p PS=2.24315789474u PD=0.65u rfmode=0
M$1831 GND \$1976 \$2026 GND sg13_lv_nmos L=0.13u W=0.3u AS=0.331736842105p
+ AD=0.0525p PS=2.24315789474u PD=0.65u rfmode=0
M$1832 GND \$1977 \$2023 GND sg13_lv_nmos L=0.13u W=0.3u AS=0.331736842105p
+ AD=0.0525p PS=2.24315789474u PD=0.65u rfmode=0
M$1833 GND \$1978 \$2021 GND sg13_lv_nmos L=0.13u W=0.3u AS=0.331736842105p
+ AD=0.0525p PS=2.24315789474u PD=0.65u rfmode=0
M$1834 GND \$1979 \$2018 GND sg13_lv_nmos L=0.13u W=0.3u AS=0.331736842105p
+ AD=0.0525p PS=2.24315789474u PD=0.65u rfmode=0
M$1835 GND \$1980 \$2015 GND sg13_lv_nmos L=0.13u W=0.3u AS=0.331736842105p
+ AD=0.0525p PS=2.24315789474u PD=0.65u rfmode=0
M$1836 GND \$1981 \$2013 GND sg13_lv_nmos L=0.13u W=0.3u AS=0.331736842105p
+ AD=0.0525p PS=2.24315789474u PD=0.65u rfmode=0
M$1837 GND \$1982 \$2010 GND sg13_lv_nmos L=0.13u W=0.3u AS=0.331736842105p
+ AD=0.0525p PS=2.24315789474u PD=0.65u rfmode=0
M$1838 GND \$1983 \$2007 GND sg13_lv_nmos L=0.13u W=0.3u AS=0.331736842105p
+ AD=0.0525p PS=2.24315789474u PD=0.65u rfmode=0
M$1839 GND \$1984 \$2005 GND sg13_lv_nmos L=0.13u W=0.3u AS=0.331736842105p
+ AD=0.0525p PS=2.24315789474u PD=0.65u rfmode=0
M$1840 GND \$1985 \$2002 GND sg13_lv_nmos L=0.13u W=0.3u AS=0.331736842105p
+ AD=0.0525p PS=2.24315789474u PD=0.65u rfmode=0
M$1841 GND \$1986 \$1999 GND sg13_lv_nmos L=0.13u W=0.3u AS=0.331736842105p
+ AD=0.0525p PS=2.24315789474u PD=0.65u rfmode=0
M$1842 GND \$1987 \$1997 GND sg13_lv_nmos L=0.13u W=0.3u AS=0.331736842105p
+ AD=0.0525p PS=2.24315789474u PD=0.65u rfmode=0
M$1843 GND \$1988 \$1995 GND sg13_lv_nmos L=0.13u W=0.3u AS=0.331736842105p
+ AD=0.0525p PS=2.24315789474u PD=0.65u rfmode=0
M$1844 \$2028 RWL[23] RBL[19] GND sg13_lv_nmos L=0.13u W=0.3u AS=0.0525p
+ AD=0.057p PS=0.65u PD=0.68u rfmode=0
M$1845 \$2029 RWL[23] RBL[20] GND sg13_lv_nmos L=0.13u W=0.3u AS=0.0525p
+ AD=0.057p PS=0.65u PD=0.68u rfmode=0
M$1846 \$2031 RWL[23] RBL[21] GND sg13_lv_nmos L=0.13u W=0.3u AS=0.0525p
+ AD=0.057p PS=0.65u PD=0.68u rfmode=0
M$1847 \$2032 RWL[23] RBL[22] GND sg13_lv_nmos L=0.13u W=0.3u AS=0.0525p
+ AD=0.057p PS=0.65u PD=0.68u rfmode=0
M$1848 \$2030 RWL[23] RBL[23] GND sg13_lv_nmos L=0.13u W=0.3u AS=0.0525p
+ AD=0.057p PS=0.65u PD=0.68u rfmode=0
M$1849 \$2027 RWL[23] RBL[24] GND sg13_lv_nmos L=0.13u W=0.3u AS=0.0525p
+ AD=0.057p PS=0.65u PD=0.68u rfmode=0
M$1850 \$2026 RWL[23] RBL[25] GND sg13_lv_nmos L=0.13u W=0.3u AS=0.0525p
+ AD=0.057p PS=0.65u PD=0.68u rfmode=0
M$1851 \$2023 RWL[23] RBL[26] GND sg13_lv_nmos L=0.13u W=0.3u AS=0.0525p
+ AD=0.057p PS=0.65u PD=0.68u rfmode=0
M$1852 \$2021 RWL[23] RBL[27] GND sg13_lv_nmos L=0.13u W=0.3u AS=0.0525p
+ AD=0.057p PS=0.65u PD=0.68u rfmode=0
M$1853 \$2018 RWL[23] RBL[28] GND sg13_lv_nmos L=0.13u W=0.3u AS=0.0525p
+ AD=0.057p PS=0.65u PD=0.68u rfmode=0
M$1854 \$2015 RWL[23] RBL[29] GND sg13_lv_nmos L=0.13u W=0.3u AS=0.0525p
+ AD=0.057p PS=0.65u PD=0.68u rfmode=0
M$1855 \$2013 RWL[23] RBL[30] GND sg13_lv_nmos L=0.13u W=0.3u AS=0.0525p
+ AD=0.057p PS=0.65u PD=0.68u rfmode=0
M$1856 \$2010 RWL[23] RBL[31] GND sg13_lv_nmos L=0.13u W=0.3u AS=0.0525p
+ AD=0.057p PS=0.65u PD=0.68u rfmode=0
M$1857 \$2007 RWL[23] RBL[32] GND sg13_lv_nmos L=0.13u W=0.3u AS=0.0525p
+ AD=0.057p PS=0.65u PD=0.68u rfmode=0
M$1858 \$2005 RWL[23] RBL[33] GND sg13_lv_nmos L=0.13u W=0.3u AS=0.0525p
+ AD=0.057p PS=0.65u PD=0.68u rfmode=0
M$1859 \$2002 RWL[23] RBL[34] GND sg13_lv_nmos L=0.13u W=0.3u AS=0.0525p
+ AD=0.057p PS=0.65u PD=0.68u rfmode=0
M$1860 \$1999 RWL[23] RBL[35] GND sg13_lv_nmos L=0.13u W=0.3u AS=0.0525p
+ AD=0.057p PS=0.65u PD=0.68u rfmode=0
M$1861 \$1997 RWL[23] RBL[36] GND sg13_lv_nmos L=0.13u W=0.3u AS=0.0525p
+ AD=0.057p PS=0.65u PD=0.68u rfmode=0
M$1862 \$1995 RWL[23] RBL[37] GND sg13_lv_nmos L=0.13u W=0.3u AS=0.0525p
+ AD=0.057p PS=0.65u PD=0.68u rfmode=0
M$1863 RBL[19] RWL[24] \$2107 GND sg13_lv_nmos L=0.13u W=0.3u AS=0.057p
+ AD=0.0525p PS=0.68u PD=0.65u rfmode=0
M$1864 RBL[20] RWL[24] \$2108 GND sg13_lv_nmos L=0.13u W=0.3u AS=0.057p
+ AD=0.0525p PS=0.68u PD=0.65u rfmode=0
M$1865 RBL[21] RWL[24] \$2110 GND sg13_lv_nmos L=0.13u W=0.3u AS=0.057p
+ AD=0.0525p PS=0.68u PD=0.65u rfmode=0
M$1866 RBL[22] RWL[24] \$2112 GND sg13_lv_nmos L=0.13u W=0.3u AS=0.057p
+ AD=0.0525p PS=0.68u PD=0.65u rfmode=0
M$1867 RBL[23] RWL[24] \$2113 GND sg13_lv_nmos L=0.13u W=0.3u AS=0.057p
+ AD=0.0525p PS=0.68u PD=0.65u rfmode=0
M$1868 RBL[24] RWL[24] \$2111 GND sg13_lv_nmos L=0.13u W=0.3u AS=0.057p
+ AD=0.0525p PS=0.68u PD=0.65u rfmode=0
M$1869 RBL[25] RWL[24] \$2109 GND sg13_lv_nmos L=0.13u W=0.3u AS=0.057p
+ AD=0.0525p PS=0.68u PD=0.65u rfmode=0
M$1870 RBL[26] RWL[24] \$2106 GND sg13_lv_nmos L=0.13u W=0.3u AS=0.057p
+ AD=0.0525p PS=0.68u PD=0.65u rfmode=0
M$1871 RBL[27] RWL[24] \$2105 GND sg13_lv_nmos L=0.13u W=0.3u AS=0.057p
+ AD=0.0525p PS=0.68u PD=0.65u rfmode=0
M$1872 RBL[28] RWL[24] \$2102 GND sg13_lv_nmos L=0.13u W=0.3u AS=0.057p
+ AD=0.0525p PS=0.68u PD=0.65u rfmode=0
M$1873 RBL[29] RWL[24] \$2100 GND sg13_lv_nmos L=0.13u W=0.3u AS=0.057p
+ AD=0.0525p PS=0.68u PD=0.65u rfmode=0
M$1874 RBL[30] RWL[24] \$2097 GND sg13_lv_nmos L=0.13u W=0.3u AS=0.057p
+ AD=0.0525p PS=0.68u PD=0.65u rfmode=0
M$1875 RBL[31] RWL[24] \$2094 GND sg13_lv_nmos L=0.13u W=0.3u AS=0.057p
+ AD=0.0525p PS=0.68u PD=0.65u rfmode=0
M$1876 RBL[32] RWL[24] \$2092 GND sg13_lv_nmos L=0.13u W=0.3u AS=0.057p
+ AD=0.0525p PS=0.68u PD=0.65u rfmode=0
M$1877 RBL[33] RWL[24] \$2089 GND sg13_lv_nmos L=0.13u W=0.3u AS=0.057p
+ AD=0.0525p PS=0.68u PD=0.65u rfmode=0
M$1878 RBL[34] RWL[24] \$2087 GND sg13_lv_nmos L=0.13u W=0.3u AS=0.057p
+ AD=0.0525p PS=0.68u PD=0.65u rfmode=0
M$1879 RBL[35] RWL[24] \$2084 GND sg13_lv_nmos L=0.13u W=0.3u AS=0.057p
+ AD=0.0525p PS=0.68u PD=0.65u rfmode=0
M$1880 RBL[36] RWL[24] \$2082 GND sg13_lv_nmos L=0.13u W=0.3u AS=0.057p
+ AD=0.0525p PS=0.68u PD=0.65u rfmode=0
M$1881 RBL[37] RWL[24] \$2079 GND sg13_lv_nmos L=0.13u W=0.3u AS=0.057p
+ AD=0.0525p PS=0.68u PD=0.65u rfmode=0
M$1882 \$2107 \$2055 GND GND sg13_lv_nmos L=0.13u W=0.3u AS=0.0525p
+ AD=0.331736842105p PS=0.65u PD=2.24315789474u rfmode=0
M$1883 \$2108 \$2056 GND GND sg13_lv_nmos L=0.13u W=0.3u AS=0.0525p
+ AD=0.331736842105p PS=0.65u PD=2.24315789474u rfmode=0
M$1884 \$2110 \$2057 GND GND sg13_lv_nmos L=0.13u W=0.3u AS=0.0525p
+ AD=0.331736842105p PS=0.65u PD=2.24315789474u rfmode=0
M$1885 \$2112 \$2058 GND GND sg13_lv_nmos L=0.13u W=0.3u AS=0.0525p
+ AD=0.331736842105p PS=0.65u PD=2.24315789474u rfmode=0
M$1886 \$2113 \$2059 GND GND sg13_lv_nmos L=0.13u W=0.3u AS=0.0525p
+ AD=0.331736842105p PS=0.65u PD=2.24315789474u rfmode=0
M$1887 \$2111 \$2060 GND GND sg13_lv_nmos L=0.13u W=0.3u AS=0.0525p
+ AD=0.331736842105p PS=0.65u PD=2.24315789474u rfmode=0
M$1888 \$2109 \$2061 GND GND sg13_lv_nmos L=0.13u W=0.3u AS=0.0525p
+ AD=0.331736842105p PS=0.65u PD=2.24315789474u rfmode=0
M$1889 \$2106 \$2062 GND GND sg13_lv_nmos L=0.13u W=0.3u AS=0.0525p
+ AD=0.331736842105p PS=0.65u PD=2.24315789474u rfmode=0
M$1890 \$2105 \$2063 GND GND sg13_lv_nmos L=0.13u W=0.3u AS=0.0525p
+ AD=0.331736842105p PS=0.65u PD=2.24315789474u rfmode=0
M$1891 \$2102 \$2064 GND GND sg13_lv_nmos L=0.13u W=0.3u AS=0.0525p
+ AD=0.331736842105p PS=0.65u PD=2.24315789474u rfmode=0
M$1892 \$2100 \$2065 GND GND sg13_lv_nmos L=0.13u W=0.3u AS=0.0525p
+ AD=0.331736842105p PS=0.65u PD=2.24315789474u rfmode=0
M$1893 \$2097 \$2066 GND GND sg13_lv_nmos L=0.13u W=0.3u AS=0.0525p
+ AD=0.331736842105p PS=0.65u PD=2.24315789474u rfmode=0
M$1894 \$2094 \$2067 GND GND sg13_lv_nmos L=0.13u W=0.3u AS=0.0525p
+ AD=0.331736842105p PS=0.65u PD=2.24315789474u rfmode=0
M$1895 \$2092 \$2068 GND GND sg13_lv_nmos L=0.13u W=0.3u AS=0.0525p
+ AD=0.331736842105p PS=0.65u PD=2.24315789474u rfmode=0
M$1896 \$2089 \$2069 GND GND sg13_lv_nmos L=0.13u W=0.3u AS=0.0525p
+ AD=0.331736842105p PS=0.65u PD=2.24315789474u rfmode=0
M$1897 \$2087 \$2070 GND GND sg13_lv_nmos L=0.13u W=0.3u AS=0.0525p
+ AD=0.331736842105p PS=0.65u PD=2.24315789474u rfmode=0
M$1898 \$2084 \$2071 GND GND sg13_lv_nmos L=0.13u W=0.3u AS=0.0525p
+ AD=0.331736842105p PS=0.65u PD=2.24315789474u rfmode=0
M$1899 \$2082 \$2072 GND GND sg13_lv_nmos L=0.13u W=0.3u AS=0.0525p
+ AD=0.331736842105p PS=0.65u PD=2.24315789474u rfmode=0
M$1900 \$2079 \$2073 GND GND sg13_lv_nmos L=0.13u W=0.3u AS=0.0525p
+ AD=0.331736842105p PS=0.65u PD=2.24315789474u rfmode=0
M$1901 GND \$2114 \$2159 GND sg13_lv_nmos L=0.13u W=0.3u AS=0.331736842105p
+ AD=0.0525p PS=2.24315789474u PD=0.65u rfmode=0
M$1902 GND \$2115 \$2161 GND sg13_lv_nmos L=0.13u W=0.3u AS=0.331736842105p
+ AD=0.0525p PS=2.24315789474u PD=0.65u rfmode=0
M$1903 GND \$2116 \$2163 GND sg13_lv_nmos L=0.13u W=0.3u AS=0.331736842105p
+ AD=0.0525p PS=2.24315789474u PD=0.65u rfmode=0
M$1904 GND \$2117 \$2164 GND sg13_lv_nmos L=0.13u W=0.3u AS=0.331736842105p
+ AD=0.0525p PS=2.24315789474u PD=0.65u rfmode=0
M$1905 GND \$2118 \$2166 GND sg13_lv_nmos L=0.13u W=0.3u AS=0.331736842105p
+ AD=0.0525p PS=2.24315789474u PD=0.65u rfmode=0
M$1906 GND \$2119 \$2167 GND sg13_lv_nmos L=0.13u W=0.3u AS=0.331736842105p
+ AD=0.0525p PS=2.24315789474u PD=0.65u rfmode=0
M$1907 GND \$2120 \$2169 GND sg13_lv_nmos L=0.13u W=0.3u AS=0.331736842105p
+ AD=0.0525p PS=2.24315789474u PD=0.65u rfmode=0
M$1908 GND \$2121 \$2171 GND sg13_lv_nmos L=0.13u W=0.3u AS=0.331736842105p
+ AD=0.0525p PS=2.24315789474u PD=0.65u rfmode=0
M$1909 GND \$2122 \$2172 GND sg13_lv_nmos L=0.13u W=0.3u AS=0.331736842105p
+ AD=0.0525p PS=2.24315789474u PD=0.65u rfmode=0
M$1910 GND \$2123 \$2174 GND sg13_lv_nmos L=0.13u W=0.3u AS=0.331736842105p
+ AD=0.0525p PS=2.24315789474u PD=0.65u rfmode=0
M$1911 GND \$2124 \$2175 GND sg13_lv_nmos L=0.13u W=0.3u AS=0.331736842105p
+ AD=0.0525p PS=2.24315789474u PD=0.65u rfmode=0
M$1912 GND \$2125 \$2177 GND sg13_lv_nmos L=0.13u W=0.3u AS=0.331736842105p
+ AD=0.0525p PS=2.24315789474u PD=0.65u rfmode=0
M$1913 GND \$2126 \$2179 GND sg13_lv_nmos L=0.13u W=0.3u AS=0.331736842105p
+ AD=0.0525p PS=2.24315789474u PD=0.65u rfmode=0
M$1914 GND \$2127 \$2180 GND sg13_lv_nmos L=0.13u W=0.3u AS=0.331736842105p
+ AD=0.0525p PS=2.24315789474u PD=0.65u rfmode=0
M$1915 GND \$2128 \$2182 GND sg13_lv_nmos L=0.13u W=0.3u AS=0.331736842105p
+ AD=0.0525p PS=2.24315789474u PD=0.65u rfmode=0
M$1916 GND \$2129 \$2184 GND sg13_lv_nmos L=0.13u W=0.3u AS=0.331736842105p
+ AD=0.0525p PS=2.24315789474u PD=0.65u rfmode=0
M$1917 GND \$2130 \$2185 GND sg13_lv_nmos L=0.13u W=0.3u AS=0.331736842105p
+ AD=0.0525p PS=2.24315789474u PD=0.65u rfmode=0
M$1918 GND \$2131 \$2187 GND sg13_lv_nmos L=0.13u W=0.3u AS=0.331736842105p
+ AD=0.0525p PS=2.24315789474u PD=0.65u rfmode=0
M$1919 GND \$2132 \$2188 GND sg13_lv_nmos L=0.13u W=0.3u AS=0.331736842105p
+ AD=0.0525p PS=2.24315789474u PD=0.65u rfmode=0
M$1920 \$2159 RWL[25] RBL[0] GND sg13_lv_nmos L=0.13u W=0.3u AS=0.0525p
+ AD=0.057p PS=0.65u PD=0.68u rfmode=0
M$1921 \$2161 RWL[25] RBL[1] GND sg13_lv_nmos L=0.13u W=0.3u AS=0.0525p
+ AD=0.057p PS=0.65u PD=0.68u rfmode=0
M$1922 \$2163 RWL[25] RBL[2] GND sg13_lv_nmos L=0.13u W=0.3u AS=0.0525p
+ AD=0.057p PS=0.65u PD=0.68u rfmode=0
M$1923 \$2164 RWL[25] RBL[3] GND sg13_lv_nmos L=0.13u W=0.3u AS=0.0525p
+ AD=0.057p PS=0.65u PD=0.68u rfmode=0
M$1924 \$2166 RWL[25] RBL[4] GND sg13_lv_nmos L=0.13u W=0.3u AS=0.0525p
+ AD=0.057p PS=0.65u PD=0.68u rfmode=0
M$1925 \$2167 RWL[25] RBL[5] GND sg13_lv_nmos L=0.13u W=0.3u AS=0.0525p
+ AD=0.057p PS=0.65u PD=0.68u rfmode=0
M$1926 \$2169 RWL[25] RBL[6] GND sg13_lv_nmos L=0.13u W=0.3u AS=0.0525p
+ AD=0.057p PS=0.65u PD=0.68u rfmode=0
M$1927 \$2171 RWL[25] RBL[7] GND sg13_lv_nmos L=0.13u W=0.3u AS=0.0525p
+ AD=0.057p PS=0.65u PD=0.68u rfmode=0
M$1928 \$2172 RWL[25] RBL[8] GND sg13_lv_nmos L=0.13u W=0.3u AS=0.0525p
+ AD=0.057p PS=0.65u PD=0.68u rfmode=0
M$1929 \$2174 RWL[25] RBL[9] GND sg13_lv_nmos L=0.13u W=0.3u AS=0.0525p
+ AD=0.057p PS=0.65u PD=0.68u rfmode=0
M$1930 \$2175 RWL[25] RBL[10] GND sg13_lv_nmos L=0.13u W=0.3u AS=0.0525p
+ AD=0.057p PS=0.65u PD=0.68u rfmode=0
M$1931 \$2177 RWL[25] RBL[11] GND sg13_lv_nmos L=0.13u W=0.3u AS=0.0525p
+ AD=0.057p PS=0.65u PD=0.68u rfmode=0
M$1932 \$2179 RWL[25] RBL[12] GND sg13_lv_nmos L=0.13u W=0.3u AS=0.0525p
+ AD=0.057p PS=0.65u PD=0.68u rfmode=0
M$1933 \$2180 RWL[25] RBL[13] GND sg13_lv_nmos L=0.13u W=0.3u AS=0.0525p
+ AD=0.057p PS=0.65u PD=0.68u rfmode=0
M$1934 \$2182 RWL[25] RBL[14] GND sg13_lv_nmos L=0.13u W=0.3u AS=0.0525p
+ AD=0.057p PS=0.65u PD=0.68u rfmode=0
M$1935 \$2184 RWL[25] RBL[15] GND sg13_lv_nmos L=0.13u W=0.3u AS=0.0525p
+ AD=0.057p PS=0.65u PD=0.68u rfmode=0
M$1936 \$2185 RWL[25] RBL[16] GND sg13_lv_nmos L=0.13u W=0.3u AS=0.0525p
+ AD=0.057p PS=0.65u PD=0.68u rfmode=0
M$1937 \$2187 RWL[25] RBL[17] GND sg13_lv_nmos L=0.13u W=0.3u AS=0.0525p
+ AD=0.057p PS=0.65u PD=0.68u rfmode=0
M$1938 \$2188 RWL[25] RBL[18] GND sg13_lv_nmos L=0.13u W=0.3u AS=0.0525p
+ AD=0.057p PS=0.65u PD=0.68u rfmode=0
M$1939 RBL[0] RWL[26] \$2239 GND sg13_lv_nmos L=0.13u W=0.3u AS=0.057p
+ AD=0.0525p PS=0.68u PD=0.65u rfmode=0
M$1940 RBL[1] RWL[26] \$2240 GND sg13_lv_nmos L=0.13u W=0.3u AS=0.057p
+ AD=0.0525p PS=0.68u PD=0.65u rfmode=0
M$1941 RBL[2] RWL[26] \$2241 GND sg13_lv_nmos L=0.13u W=0.3u AS=0.057p
+ AD=0.0525p PS=0.68u PD=0.65u rfmode=0
M$1942 RBL[3] RWL[26] \$2243 GND sg13_lv_nmos L=0.13u W=0.3u AS=0.057p
+ AD=0.0525p PS=0.68u PD=0.65u rfmode=0
M$1943 RBL[4] RWL[26] \$2244 GND sg13_lv_nmos L=0.13u W=0.3u AS=0.057p
+ AD=0.0525p PS=0.68u PD=0.65u rfmode=0
M$1944 RBL[5] RWL[26] \$2246 GND sg13_lv_nmos L=0.13u W=0.3u AS=0.057p
+ AD=0.0525p PS=0.68u PD=0.65u rfmode=0
M$1945 RBL[6] RWL[26] \$2248 GND sg13_lv_nmos L=0.13u W=0.3u AS=0.057p
+ AD=0.0525p PS=0.68u PD=0.65u rfmode=0
M$1946 RBL[7] RWL[26] \$2249 GND sg13_lv_nmos L=0.13u W=0.3u AS=0.057p
+ AD=0.0525p PS=0.68u PD=0.65u rfmode=0
M$1947 RBL[8] RWL[26] \$2251 GND sg13_lv_nmos L=0.13u W=0.3u AS=0.057p
+ AD=0.0525p PS=0.68u PD=0.65u rfmode=0
M$1948 RBL[9] RWL[26] \$2253 GND sg13_lv_nmos L=0.13u W=0.3u AS=0.057p
+ AD=0.0525p PS=0.68u PD=0.65u rfmode=0
M$1949 RBL[10] RWL[26] \$2255 GND sg13_lv_nmos L=0.13u W=0.3u AS=0.057p
+ AD=0.0525p PS=0.68u PD=0.65u rfmode=0
M$1950 RBL[11] RWL[26] \$2256 GND sg13_lv_nmos L=0.13u W=0.3u AS=0.057p
+ AD=0.0525p PS=0.68u PD=0.65u rfmode=0
M$1951 RBL[12] RWL[26] \$2258 GND sg13_lv_nmos L=0.13u W=0.3u AS=0.057p
+ AD=0.0525p PS=0.68u PD=0.65u rfmode=0
M$1952 RBL[13] RWL[26] \$2259 GND sg13_lv_nmos L=0.13u W=0.3u AS=0.057p
+ AD=0.0525p PS=0.68u PD=0.65u rfmode=0
M$1953 RBL[14] RWL[26] \$2261 GND sg13_lv_nmos L=0.13u W=0.3u AS=0.057p
+ AD=0.0525p PS=0.68u PD=0.65u rfmode=0
M$1954 RBL[15] RWL[26] \$2263 GND sg13_lv_nmos L=0.13u W=0.3u AS=0.057p
+ AD=0.0525p PS=0.68u PD=0.65u rfmode=0
M$1955 RBL[16] RWL[26] \$2264 GND sg13_lv_nmos L=0.13u W=0.3u AS=0.057p
+ AD=0.0525p PS=0.68u PD=0.65u rfmode=0
M$1956 RBL[17] RWL[26] \$2266 GND sg13_lv_nmos L=0.13u W=0.3u AS=0.057p
+ AD=0.0525p PS=0.68u PD=0.65u rfmode=0
M$1957 RBL[18] RWL[26] \$2267 GND sg13_lv_nmos L=0.13u W=0.3u AS=0.057p
+ AD=0.0525p PS=0.68u PD=0.65u rfmode=0
M$1958 \$2239 \$2199 GND GND sg13_lv_nmos L=0.13u W=0.3u AS=0.0525p
+ AD=0.331736842105p PS=0.65u PD=2.24315789474u rfmode=0
M$1959 \$2240 \$2200 GND GND sg13_lv_nmos L=0.13u W=0.3u AS=0.0525p
+ AD=0.331736842105p PS=0.65u PD=2.24315789474u rfmode=0
M$1960 \$2241 \$2201 GND GND sg13_lv_nmos L=0.13u W=0.3u AS=0.0525p
+ AD=0.331736842105p PS=0.65u PD=2.24315789474u rfmode=0
M$1961 \$2243 \$2202 GND GND sg13_lv_nmos L=0.13u W=0.3u AS=0.0525p
+ AD=0.331736842105p PS=0.65u PD=2.24315789474u rfmode=0
M$1962 \$2244 \$2203 GND GND sg13_lv_nmos L=0.13u W=0.3u AS=0.0525p
+ AD=0.331736842105p PS=0.65u PD=2.24315789474u rfmode=0
M$1963 \$2246 \$2204 GND GND sg13_lv_nmos L=0.13u W=0.3u AS=0.0525p
+ AD=0.331736842105p PS=0.65u PD=2.24315789474u rfmode=0
M$1964 \$2248 \$2205 GND GND sg13_lv_nmos L=0.13u W=0.3u AS=0.0525p
+ AD=0.331736842105p PS=0.65u PD=2.24315789474u rfmode=0
M$1965 \$2249 \$2206 GND GND sg13_lv_nmos L=0.13u W=0.3u AS=0.0525p
+ AD=0.331736842105p PS=0.65u PD=2.24315789474u rfmode=0
M$1966 \$2251 \$2207 GND GND sg13_lv_nmos L=0.13u W=0.3u AS=0.0525p
+ AD=0.331736842105p PS=0.65u PD=2.24315789474u rfmode=0
M$1967 \$2253 \$2208 GND GND sg13_lv_nmos L=0.13u W=0.3u AS=0.0525p
+ AD=0.331736842105p PS=0.65u PD=2.24315789474u rfmode=0
M$1968 \$2255 \$2209 GND GND sg13_lv_nmos L=0.13u W=0.3u AS=0.0525p
+ AD=0.331736842105p PS=0.65u PD=2.24315789474u rfmode=0
M$1969 \$2256 \$2210 GND GND sg13_lv_nmos L=0.13u W=0.3u AS=0.0525p
+ AD=0.331736842105p PS=0.65u PD=2.24315789474u rfmode=0
M$1970 \$2258 \$2211 GND GND sg13_lv_nmos L=0.13u W=0.3u AS=0.0525p
+ AD=0.331736842105p PS=0.65u PD=2.24315789474u rfmode=0
M$1971 \$2259 \$2212 GND GND sg13_lv_nmos L=0.13u W=0.3u AS=0.0525p
+ AD=0.331736842105p PS=0.65u PD=2.24315789474u rfmode=0
M$1972 \$2261 \$2213 GND GND sg13_lv_nmos L=0.13u W=0.3u AS=0.0525p
+ AD=0.331736842105p PS=0.65u PD=2.24315789474u rfmode=0
M$1973 \$2263 \$2214 GND GND sg13_lv_nmos L=0.13u W=0.3u AS=0.0525p
+ AD=0.331736842105p PS=0.65u PD=2.24315789474u rfmode=0
M$1974 \$2264 \$2215 GND GND sg13_lv_nmos L=0.13u W=0.3u AS=0.0525p
+ AD=0.331736842105p PS=0.65u PD=2.24315789474u rfmode=0
M$1975 \$2266 \$2216 GND GND sg13_lv_nmos L=0.13u W=0.3u AS=0.0525p
+ AD=0.331736842105p PS=0.65u PD=2.24315789474u rfmode=0
M$1976 \$2267 \$2217 GND GND sg13_lv_nmos L=0.13u W=0.3u AS=0.0525p
+ AD=0.331736842105p PS=0.65u PD=2.24315789474u rfmode=0
M$1977 GND \$2133 \$2190 GND sg13_lv_nmos L=0.13u W=0.3u AS=0.331736842105p
+ AD=0.0525p PS=2.24315789474u PD=0.65u rfmode=0
M$1978 GND \$2134 \$2192 GND sg13_lv_nmos L=0.13u W=0.3u AS=0.331736842105p
+ AD=0.0525p PS=2.24315789474u PD=0.65u rfmode=0
M$1979 GND \$2135 \$2194 GND sg13_lv_nmos L=0.13u W=0.3u AS=0.331736842105p
+ AD=0.0525p PS=2.24315789474u PD=0.65u rfmode=0
M$1980 GND \$2136 \$2195 GND sg13_lv_nmos L=0.13u W=0.3u AS=0.331736842105p
+ AD=0.0525p PS=2.24315789474u PD=0.65u rfmode=0
M$1981 GND \$2137 \$2193 GND sg13_lv_nmos L=0.13u W=0.3u AS=0.331736842105p
+ AD=0.0525p PS=2.24315789474u PD=0.65u rfmode=0
M$1982 GND \$2138 \$2191 GND sg13_lv_nmos L=0.13u W=0.3u AS=0.331736842105p
+ AD=0.0525p PS=2.24315789474u PD=0.65u rfmode=0
M$1983 GND \$2139 \$2189 GND sg13_lv_nmos L=0.13u W=0.3u AS=0.331736842105p
+ AD=0.0525p PS=2.24315789474u PD=0.65u rfmode=0
M$1984 GND \$2140 \$2186 GND sg13_lv_nmos L=0.13u W=0.3u AS=0.331736842105p
+ AD=0.0525p PS=2.24315789474u PD=0.65u rfmode=0
M$1985 GND \$2141 \$2183 GND sg13_lv_nmos L=0.13u W=0.3u AS=0.331736842105p
+ AD=0.0525p PS=2.24315789474u PD=0.65u rfmode=0
M$1986 GND \$2142 \$2181 GND sg13_lv_nmos L=0.13u W=0.3u AS=0.331736842105p
+ AD=0.0525p PS=2.24315789474u PD=0.65u rfmode=0
M$1987 GND \$2143 \$2178 GND sg13_lv_nmos L=0.13u W=0.3u AS=0.331736842105p
+ AD=0.0525p PS=2.24315789474u PD=0.65u rfmode=0
M$1988 GND \$2144 \$2176 GND sg13_lv_nmos L=0.13u W=0.3u AS=0.331736842105p
+ AD=0.0525p PS=2.24315789474u PD=0.65u rfmode=0
M$1989 GND \$2145 \$2173 GND sg13_lv_nmos L=0.13u W=0.3u AS=0.331736842105p
+ AD=0.0525p PS=2.24315789474u PD=0.65u rfmode=0
M$1990 GND \$2146 \$2170 GND sg13_lv_nmos L=0.13u W=0.3u AS=0.331736842105p
+ AD=0.0525p PS=2.24315789474u PD=0.65u rfmode=0
M$1991 GND \$2147 \$2168 GND sg13_lv_nmos L=0.13u W=0.3u AS=0.331736842105p
+ AD=0.0525p PS=2.24315789474u PD=0.65u rfmode=0
M$1992 GND \$2148 \$2165 GND sg13_lv_nmos L=0.13u W=0.3u AS=0.331736842105p
+ AD=0.0525p PS=2.24315789474u PD=0.65u rfmode=0
M$1993 GND \$2149 \$2162 GND sg13_lv_nmos L=0.13u W=0.3u AS=0.331736842105p
+ AD=0.0525p PS=2.24315789474u PD=0.65u rfmode=0
M$1994 GND \$2150 \$2160 GND sg13_lv_nmos L=0.13u W=0.3u AS=0.331736842105p
+ AD=0.0525p PS=2.24315789474u PD=0.65u rfmode=0
M$1995 GND \$2151 \$2158 GND sg13_lv_nmos L=0.13u W=0.3u AS=0.331736842105p
+ AD=0.0525p PS=2.24315789474u PD=0.65u rfmode=0
M$1996 \$2190 RWL[25] RBL[19] GND sg13_lv_nmos L=0.13u W=0.3u AS=0.0525p
+ AD=0.057p PS=0.65u PD=0.68u rfmode=0
M$1997 \$2192 RWL[25] RBL[20] GND sg13_lv_nmos L=0.13u W=0.3u AS=0.0525p
+ AD=0.057p PS=0.65u PD=0.68u rfmode=0
M$1998 \$2194 RWL[25] RBL[21] GND sg13_lv_nmos L=0.13u W=0.3u AS=0.0525p
+ AD=0.057p PS=0.65u PD=0.68u rfmode=0
M$1999 \$2195 RWL[25] RBL[22] GND sg13_lv_nmos L=0.13u W=0.3u AS=0.0525p
+ AD=0.057p PS=0.65u PD=0.68u rfmode=0
M$2000 \$2193 RWL[25] RBL[23] GND sg13_lv_nmos L=0.13u W=0.3u AS=0.0525p
+ AD=0.057p PS=0.65u PD=0.68u rfmode=0
M$2001 \$2191 RWL[25] RBL[24] GND sg13_lv_nmos L=0.13u W=0.3u AS=0.0525p
+ AD=0.057p PS=0.65u PD=0.68u rfmode=0
M$2002 \$2189 RWL[25] RBL[25] GND sg13_lv_nmos L=0.13u W=0.3u AS=0.0525p
+ AD=0.057p PS=0.65u PD=0.68u rfmode=0
M$2003 \$2186 RWL[25] RBL[26] GND sg13_lv_nmos L=0.13u W=0.3u AS=0.0525p
+ AD=0.057p PS=0.65u PD=0.68u rfmode=0
M$2004 \$2183 RWL[25] RBL[27] GND sg13_lv_nmos L=0.13u W=0.3u AS=0.0525p
+ AD=0.057p PS=0.65u PD=0.68u rfmode=0
M$2005 \$2181 RWL[25] RBL[28] GND sg13_lv_nmos L=0.13u W=0.3u AS=0.0525p
+ AD=0.057p PS=0.65u PD=0.68u rfmode=0
M$2006 \$2178 RWL[25] RBL[29] GND sg13_lv_nmos L=0.13u W=0.3u AS=0.0525p
+ AD=0.057p PS=0.65u PD=0.68u rfmode=0
M$2007 \$2176 RWL[25] RBL[30] GND sg13_lv_nmos L=0.13u W=0.3u AS=0.0525p
+ AD=0.057p PS=0.65u PD=0.68u rfmode=0
M$2008 \$2173 RWL[25] RBL[31] GND sg13_lv_nmos L=0.13u W=0.3u AS=0.0525p
+ AD=0.057p PS=0.65u PD=0.68u rfmode=0
M$2009 \$2170 RWL[25] RBL[32] GND sg13_lv_nmos L=0.13u W=0.3u AS=0.0525p
+ AD=0.057p PS=0.65u PD=0.68u rfmode=0
M$2010 \$2168 RWL[25] RBL[33] GND sg13_lv_nmos L=0.13u W=0.3u AS=0.0525p
+ AD=0.057p PS=0.65u PD=0.68u rfmode=0
M$2011 \$2165 RWL[25] RBL[34] GND sg13_lv_nmos L=0.13u W=0.3u AS=0.0525p
+ AD=0.057p PS=0.65u PD=0.68u rfmode=0
M$2012 \$2162 RWL[25] RBL[35] GND sg13_lv_nmos L=0.13u W=0.3u AS=0.0525p
+ AD=0.057p PS=0.65u PD=0.68u rfmode=0
M$2013 \$2160 RWL[25] RBL[36] GND sg13_lv_nmos L=0.13u W=0.3u AS=0.0525p
+ AD=0.057p PS=0.65u PD=0.68u rfmode=0
M$2014 \$2158 RWL[25] RBL[37] GND sg13_lv_nmos L=0.13u W=0.3u AS=0.0525p
+ AD=0.057p PS=0.65u PD=0.68u rfmode=0
M$2015 RBL[19] RWL[26] \$2270 GND sg13_lv_nmos L=0.13u W=0.3u AS=0.057p
+ AD=0.0525p PS=0.68u PD=0.65u rfmode=0
M$2016 RBL[20] RWL[26] \$2271 GND sg13_lv_nmos L=0.13u W=0.3u AS=0.057p
+ AD=0.0525p PS=0.68u PD=0.65u rfmode=0
M$2017 RBL[21] RWL[26] \$2273 GND sg13_lv_nmos L=0.13u W=0.3u AS=0.057p
+ AD=0.0525p PS=0.68u PD=0.65u rfmode=0
M$2018 RBL[22] RWL[26] \$2275 GND sg13_lv_nmos L=0.13u W=0.3u AS=0.057p
+ AD=0.0525p PS=0.68u PD=0.65u rfmode=0
M$2019 RBL[23] RWL[26] \$2276 GND sg13_lv_nmos L=0.13u W=0.3u AS=0.057p
+ AD=0.0525p PS=0.68u PD=0.65u rfmode=0
M$2020 RBL[24] RWL[26] \$2274 GND sg13_lv_nmos L=0.13u W=0.3u AS=0.057p
+ AD=0.0525p PS=0.68u PD=0.65u rfmode=0
M$2021 RBL[25] RWL[26] \$2272 GND sg13_lv_nmos L=0.13u W=0.3u AS=0.057p
+ AD=0.0525p PS=0.68u PD=0.65u rfmode=0
M$2022 RBL[26] RWL[26] \$2269 GND sg13_lv_nmos L=0.13u W=0.3u AS=0.057p
+ AD=0.0525p PS=0.68u PD=0.65u rfmode=0
M$2023 RBL[27] RWL[26] \$2268 GND sg13_lv_nmos L=0.13u W=0.3u AS=0.057p
+ AD=0.0525p PS=0.68u PD=0.65u rfmode=0
M$2024 RBL[28] RWL[26] \$2265 GND sg13_lv_nmos L=0.13u W=0.3u AS=0.057p
+ AD=0.0525p PS=0.68u PD=0.65u rfmode=0
M$2025 RBL[29] RWL[26] \$2262 GND sg13_lv_nmos L=0.13u W=0.3u AS=0.057p
+ AD=0.0525p PS=0.68u PD=0.65u rfmode=0
M$2026 RBL[30] RWL[26] \$2260 GND sg13_lv_nmos L=0.13u W=0.3u AS=0.057p
+ AD=0.0525p PS=0.68u PD=0.65u rfmode=0
M$2027 RBL[31] RWL[26] \$2257 GND sg13_lv_nmos L=0.13u W=0.3u AS=0.057p
+ AD=0.0525p PS=0.68u PD=0.65u rfmode=0
M$2028 RBL[32] RWL[26] \$2254 GND sg13_lv_nmos L=0.13u W=0.3u AS=0.057p
+ AD=0.0525p PS=0.68u PD=0.65u rfmode=0
M$2029 RBL[33] RWL[26] \$2252 GND sg13_lv_nmos L=0.13u W=0.3u AS=0.057p
+ AD=0.0525p PS=0.68u PD=0.65u rfmode=0
M$2030 RBL[34] RWL[26] \$2250 GND sg13_lv_nmos L=0.13u W=0.3u AS=0.057p
+ AD=0.0525p PS=0.68u PD=0.65u rfmode=0
M$2031 RBL[35] RWL[26] \$2247 GND sg13_lv_nmos L=0.13u W=0.3u AS=0.057p
+ AD=0.0525p PS=0.68u PD=0.65u rfmode=0
M$2032 RBL[36] RWL[26] \$2245 GND sg13_lv_nmos L=0.13u W=0.3u AS=0.057p
+ AD=0.0525p PS=0.68u PD=0.65u rfmode=0
M$2033 RBL[37] RWL[26] \$2242 GND sg13_lv_nmos L=0.13u W=0.3u AS=0.057p
+ AD=0.0525p PS=0.68u PD=0.65u rfmode=0
M$2034 \$2270 \$2218 GND GND sg13_lv_nmos L=0.13u W=0.3u AS=0.0525p
+ AD=0.331736842105p PS=0.65u PD=2.24315789474u rfmode=0
M$2035 \$2271 \$2219 GND GND sg13_lv_nmos L=0.13u W=0.3u AS=0.0525p
+ AD=0.331736842105p PS=0.65u PD=2.24315789474u rfmode=0
M$2036 \$2273 \$2220 GND GND sg13_lv_nmos L=0.13u W=0.3u AS=0.0525p
+ AD=0.331736842105p PS=0.65u PD=2.24315789474u rfmode=0
M$2037 \$2275 \$2221 GND GND sg13_lv_nmos L=0.13u W=0.3u AS=0.0525p
+ AD=0.331736842105p PS=0.65u PD=2.24315789474u rfmode=0
M$2038 \$2276 \$2222 GND GND sg13_lv_nmos L=0.13u W=0.3u AS=0.0525p
+ AD=0.331736842105p PS=0.65u PD=2.24315789474u rfmode=0
M$2039 \$2274 \$2223 GND GND sg13_lv_nmos L=0.13u W=0.3u AS=0.0525p
+ AD=0.331736842105p PS=0.65u PD=2.24315789474u rfmode=0
M$2040 \$2272 \$2224 GND GND sg13_lv_nmos L=0.13u W=0.3u AS=0.0525p
+ AD=0.331736842105p PS=0.65u PD=2.24315789474u rfmode=0
M$2041 \$2269 \$2225 GND GND sg13_lv_nmos L=0.13u W=0.3u AS=0.0525p
+ AD=0.331736842105p PS=0.65u PD=2.24315789474u rfmode=0
M$2042 \$2268 \$2226 GND GND sg13_lv_nmos L=0.13u W=0.3u AS=0.0525p
+ AD=0.331736842105p PS=0.65u PD=2.24315789474u rfmode=0
M$2043 \$2265 \$2227 GND GND sg13_lv_nmos L=0.13u W=0.3u AS=0.0525p
+ AD=0.331736842105p PS=0.65u PD=2.24315789474u rfmode=0
M$2044 \$2262 \$2228 GND GND sg13_lv_nmos L=0.13u W=0.3u AS=0.0525p
+ AD=0.331736842105p PS=0.65u PD=2.24315789474u rfmode=0
M$2045 \$2260 \$2229 GND GND sg13_lv_nmos L=0.13u W=0.3u AS=0.0525p
+ AD=0.331736842105p PS=0.65u PD=2.24315789474u rfmode=0
M$2046 \$2257 \$2230 GND GND sg13_lv_nmos L=0.13u W=0.3u AS=0.0525p
+ AD=0.331736842105p PS=0.65u PD=2.24315789474u rfmode=0
M$2047 \$2254 \$2231 GND GND sg13_lv_nmos L=0.13u W=0.3u AS=0.0525p
+ AD=0.331736842105p PS=0.65u PD=2.24315789474u rfmode=0
M$2048 \$2252 \$2232 GND GND sg13_lv_nmos L=0.13u W=0.3u AS=0.0525p
+ AD=0.331736842105p PS=0.65u PD=2.24315789474u rfmode=0
M$2049 \$2250 \$2233 GND GND sg13_lv_nmos L=0.13u W=0.3u AS=0.0525p
+ AD=0.331736842105p PS=0.65u PD=2.24315789474u rfmode=0
M$2050 \$2247 \$2234 GND GND sg13_lv_nmos L=0.13u W=0.3u AS=0.0525p
+ AD=0.331736842105p PS=0.65u PD=2.24315789474u rfmode=0
M$2051 \$2245 \$2235 GND GND sg13_lv_nmos L=0.13u W=0.3u AS=0.0525p
+ AD=0.331736842105p PS=0.65u PD=2.24315789474u rfmode=0
M$2052 \$2242 \$2236 GND GND sg13_lv_nmos L=0.13u W=0.3u AS=0.0525p
+ AD=0.331736842105p PS=0.65u PD=2.24315789474u rfmode=0
M$2053 GND \$2277 \$2322 GND sg13_lv_nmos L=0.13u W=0.3u AS=0.331736842105p
+ AD=0.0525p PS=2.24315789474u PD=0.65u rfmode=0
M$2054 GND \$2278 \$2324 GND sg13_lv_nmos L=0.13u W=0.3u AS=0.331736842105p
+ AD=0.0525p PS=2.24315789474u PD=0.65u rfmode=0
M$2055 GND \$2279 \$2325 GND sg13_lv_nmos L=0.13u W=0.3u AS=0.331736842105p
+ AD=0.0525p PS=2.24315789474u PD=0.65u rfmode=0
M$2056 GND \$2280 \$2327 GND sg13_lv_nmos L=0.13u W=0.3u AS=0.331736842105p
+ AD=0.0525p PS=2.24315789474u PD=0.65u rfmode=0
M$2057 GND \$2281 \$2328 GND sg13_lv_nmos L=0.13u W=0.3u AS=0.331736842105p
+ AD=0.0525p PS=2.24315789474u PD=0.65u rfmode=0
M$2058 GND \$2282 \$2330 GND sg13_lv_nmos L=0.13u W=0.3u AS=0.331736842105p
+ AD=0.0525p PS=2.24315789474u PD=0.65u rfmode=0
M$2059 GND \$2283 \$2332 GND sg13_lv_nmos L=0.13u W=0.3u AS=0.331736842105p
+ AD=0.0525p PS=2.24315789474u PD=0.65u rfmode=0
M$2060 GND \$2284 \$2334 GND sg13_lv_nmos L=0.13u W=0.3u AS=0.331736842105p
+ AD=0.0525p PS=2.24315789474u PD=0.65u rfmode=0
M$2061 GND \$2285 \$2335 GND sg13_lv_nmos L=0.13u W=0.3u AS=0.331736842105p
+ AD=0.0525p PS=2.24315789474u PD=0.65u rfmode=0
M$2062 GND \$2286 \$2337 GND sg13_lv_nmos L=0.13u W=0.3u AS=0.331736842105p
+ AD=0.0525p PS=2.24315789474u PD=0.65u rfmode=0
M$2063 GND \$2287 \$2338 GND sg13_lv_nmos L=0.13u W=0.3u AS=0.331736842105p
+ AD=0.0525p PS=2.24315789474u PD=0.65u rfmode=0
M$2064 GND \$2288 \$2340 GND sg13_lv_nmos L=0.13u W=0.3u AS=0.331736842105p
+ AD=0.0525p PS=2.24315789474u PD=0.65u rfmode=0
M$2065 GND \$2289 \$2342 GND sg13_lv_nmos L=0.13u W=0.3u AS=0.331736842105p
+ AD=0.0525p PS=2.24315789474u PD=0.65u rfmode=0
M$2066 GND \$2290 \$2343 GND sg13_lv_nmos L=0.13u W=0.3u AS=0.331736842105p
+ AD=0.0525p PS=2.24315789474u PD=0.65u rfmode=0
M$2067 GND \$2291 \$2345 GND sg13_lv_nmos L=0.13u W=0.3u AS=0.331736842105p
+ AD=0.0525p PS=2.24315789474u PD=0.65u rfmode=0
M$2068 GND \$2292 \$2347 GND sg13_lv_nmos L=0.13u W=0.3u AS=0.331736842105p
+ AD=0.0525p PS=2.24315789474u PD=0.65u rfmode=0
M$2069 GND \$2293 \$2348 GND sg13_lv_nmos L=0.13u W=0.3u AS=0.331736842105p
+ AD=0.0525p PS=2.24315789474u PD=0.65u rfmode=0
M$2070 GND \$2294 \$2350 GND sg13_lv_nmos L=0.13u W=0.3u AS=0.331736842105p
+ AD=0.0525p PS=2.24315789474u PD=0.65u rfmode=0
M$2071 GND \$2295 \$2351 GND sg13_lv_nmos L=0.13u W=0.3u AS=0.331736842105p
+ AD=0.0525p PS=2.24315789474u PD=0.65u rfmode=0
M$2072 \$2322 RWL[27] RBL[0] GND sg13_lv_nmos L=0.13u W=0.3u AS=0.0525p
+ AD=0.057p PS=0.65u PD=0.68u rfmode=0
M$2073 \$2324 RWL[27] RBL[1] GND sg13_lv_nmos L=0.13u W=0.3u AS=0.0525p
+ AD=0.057p PS=0.65u PD=0.68u rfmode=0
M$2074 \$2325 RWL[27] RBL[2] GND sg13_lv_nmos L=0.13u W=0.3u AS=0.0525p
+ AD=0.057p PS=0.65u PD=0.68u rfmode=0
M$2075 \$2327 RWL[27] RBL[3] GND sg13_lv_nmos L=0.13u W=0.3u AS=0.0525p
+ AD=0.057p PS=0.65u PD=0.68u rfmode=0
M$2076 \$2328 RWL[27] RBL[4] GND sg13_lv_nmos L=0.13u W=0.3u AS=0.0525p
+ AD=0.057p PS=0.65u PD=0.68u rfmode=0
M$2077 \$2330 RWL[27] RBL[5] GND sg13_lv_nmos L=0.13u W=0.3u AS=0.0525p
+ AD=0.057p PS=0.65u PD=0.68u rfmode=0
M$2078 \$2332 RWL[27] RBL[6] GND sg13_lv_nmos L=0.13u W=0.3u AS=0.0525p
+ AD=0.057p PS=0.65u PD=0.68u rfmode=0
M$2079 \$2334 RWL[27] RBL[7] GND sg13_lv_nmos L=0.13u W=0.3u AS=0.0525p
+ AD=0.057p PS=0.65u PD=0.68u rfmode=0
M$2080 \$2335 RWL[27] RBL[8] GND sg13_lv_nmos L=0.13u W=0.3u AS=0.0525p
+ AD=0.057p PS=0.65u PD=0.68u rfmode=0
M$2081 \$2337 RWL[27] RBL[9] GND sg13_lv_nmos L=0.13u W=0.3u AS=0.0525p
+ AD=0.057p PS=0.65u PD=0.68u rfmode=0
M$2082 \$2338 RWL[27] RBL[10] GND sg13_lv_nmos L=0.13u W=0.3u AS=0.0525p
+ AD=0.057p PS=0.65u PD=0.68u rfmode=0
M$2083 \$2340 RWL[27] RBL[11] GND sg13_lv_nmos L=0.13u W=0.3u AS=0.0525p
+ AD=0.057p PS=0.65u PD=0.68u rfmode=0
M$2084 \$2342 RWL[27] RBL[12] GND sg13_lv_nmos L=0.13u W=0.3u AS=0.0525p
+ AD=0.057p PS=0.65u PD=0.68u rfmode=0
M$2085 \$2343 RWL[27] RBL[13] GND sg13_lv_nmos L=0.13u W=0.3u AS=0.0525p
+ AD=0.057p PS=0.65u PD=0.68u rfmode=0
M$2086 \$2345 RWL[27] RBL[14] GND sg13_lv_nmos L=0.13u W=0.3u AS=0.0525p
+ AD=0.057p PS=0.65u PD=0.68u rfmode=0
M$2087 \$2347 RWL[27] RBL[15] GND sg13_lv_nmos L=0.13u W=0.3u AS=0.0525p
+ AD=0.057p PS=0.65u PD=0.68u rfmode=0
M$2088 \$2348 RWL[27] RBL[16] GND sg13_lv_nmos L=0.13u W=0.3u AS=0.0525p
+ AD=0.057p PS=0.65u PD=0.68u rfmode=0
M$2089 \$2350 RWL[27] RBL[17] GND sg13_lv_nmos L=0.13u W=0.3u AS=0.0525p
+ AD=0.057p PS=0.65u PD=0.68u rfmode=0
M$2090 \$2351 RWL[27] RBL[18] GND sg13_lv_nmos L=0.13u W=0.3u AS=0.0525p
+ AD=0.057p PS=0.65u PD=0.68u rfmode=0
M$2091 RBL[0] RWL[28] \$2402 GND sg13_lv_nmos L=0.13u W=0.3u AS=0.057p
+ AD=0.0525p PS=0.68u PD=0.65u rfmode=0
M$2092 RBL[1] RWL[28] \$2403 GND sg13_lv_nmos L=0.13u W=0.3u AS=0.057p
+ AD=0.0525p PS=0.68u PD=0.65u rfmode=0
M$2093 RBL[2] RWL[28] \$2404 GND sg13_lv_nmos L=0.13u W=0.3u AS=0.057p
+ AD=0.0525p PS=0.68u PD=0.65u rfmode=0
M$2094 RBL[3] RWL[28] \$2406 GND sg13_lv_nmos L=0.13u W=0.3u AS=0.057p
+ AD=0.0525p PS=0.68u PD=0.65u rfmode=0
M$2095 RBL[4] RWL[28] \$2407 GND sg13_lv_nmos L=0.13u W=0.3u AS=0.057p
+ AD=0.0525p PS=0.68u PD=0.65u rfmode=0
M$2096 RBL[5] RWL[28] \$2409 GND sg13_lv_nmos L=0.13u W=0.3u AS=0.057p
+ AD=0.0525p PS=0.68u PD=0.65u rfmode=0
M$2097 RBL[6] RWL[28] \$2411 GND sg13_lv_nmos L=0.13u W=0.3u AS=0.057p
+ AD=0.0525p PS=0.68u PD=0.65u rfmode=0
M$2098 RBL[7] RWL[28] \$2412 GND sg13_lv_nmos L=0.13u W=0.3u AS=0.057p
+ AD=0.0525p PS=0.68u PD=0.65u rfmode=0
M$2099 RBL[8] RWL[28] \$2414 GND sg13_lv_nmos L=0.13u W=0.3u AS=0.057p
+ AD=0.0525p PS=0.68u PD=0.65u rfmode=0
M$2100 RBL[9] RWL[28] \$2416 GND sg13_lv_nmos L=0.13u W=0.3u AS=0.057p
+ AD=0.0525p PS=0.68u PD=0.65u rfmode=0
M$2101 RBL[10] RWL[28] \$2417 GND sg13_lv_nmos L=0.13u W=0.3u AS=0.057p
+ AD=0.0525p PS=0.68u PD=0.65u rfmode=0
M$2102 RBL[11] RWL[28] \$2419 GND sg13_lv_nmos L=0.13u W=0.3u AS=0.057p
+ AD=0.0525p PS=0.68u PD=0.65u rfmode=0
M$2103 RBL[12] RWL[28] \$2421 GND sg13_lv_nmos L=0.13u W=0.3u AS=0.057p
+ AD=0.0525p PS=0.68u PD=0.65u rfmode=0
M$2104 RBL[13] RWL[28] \$2422 GND sg13_lv_nmos L=0.13u W=0.3u AS=0.057p
+ AD=0.0525p PS=0.68u PD=0.65u rfmode=0
M$2105 RBL[14] RWL[28] \$2424 GND sg13_lv_nmos L=0.13u W=0.3u AS=0.057p
+ AD=0.0525p PS=0.68u PD=0.65u rfmode=0
M$2106 RBL[15] RWL[28] \$2425 GND sg13_lv_nmos L=0.13u W=0.3u AS=0.057p
+ AD=0.0525p PS=0.68u PD=0.65u rfmode=0
M$2107 RBL[16] RWL[28] \$2427 GND sg13_lv_nmos L=0.13u W=0.3u AS=0.057p
+ AD=0.0525p PS=0.68u PD=0.65u rfmode=0
M$2108 RBL[17] RWL[28] \$2429 GND sg13_lv_nmos L=0.13u W=0.3u AS=0.057p
+ AD=0.0525p PS=0.68u PD=0.65u rfmode=0
M$2109 RBL[18] RWL[28] \$2430 GND sg13_lv_nmos L=0.13u W=0.3u AS=0.057p
+ AD=0.0525p PS=0.68u PD=0.65u rfmode=0
M$2110 \$2402 \$2362 GND GND sg13_lv_nmos L=0.13u W=0.3u AS=0.0525p
+ AD=0.331736842105p PS=0.65u PD=2.24315789474u rfmode=0
M$2111 \$2403 \$2363 GND GND sg13_lv_nmos L=0.13u W=0.3u AS=0.0525p
+ AD=0.331736842105p PS=0.65u PD=2.24315789474u rfmode=0
M$2112 \$2404 \$2364 GND GND sg13_lv_nmos L=0.13u W=0.3u AS=0.0525p
+ AD=0.331736842105p PS=0.65u PD=2.24315789474u rfmode=0
M$2113 \$2406 \$2365 GND GND sg13_lv_nmos L=0.13u W=0.3u AS=0.0525p
+ AD=0.331736842105p PS=0.65u PD=2.24315789474u rfmode=0
M$2114 \$2407 \$2366 GND GND sg13_lv_nmos L=0.13u W=0.3u AS=0.0525p
+ AD=0.331736842105p PS=0.65u PD=2.24315789474u rfmode=0
M$2115 \$2409 \$2367 GND GND sg13_lv_nmos L=0.13u W=0.3u AS=0.0525p
+ AD=0.331736842105p PS=0.65u PD=2.24315789474u rfmode=0
M$2116 \$2411 \$2368 GND GND sg13_lv_nmos L=0.13u W=0.3u AS=0.0525p
+ AD=0.331736842105p PS=0.65u PD=2.24315789474u rfmode=0
M$2117 \$2412 \$2369 GND GND sg13_lv_nmos L=0.13u W=0.3u AS=0.0525p
+ AD=0.331736842105p PS=0.65u PD=2.24315789474u rfmode=0
M$2118 \$2414 \$2370 GND GND sg13_lv_nmos L=0.13u W=0.3u AS=0.0525p
+ AD=0.331736842105p PS=0.65u PD=2.24315789474u rfmode=0
M$2119 \$2416 \$2371 GND GND sg13_lv_nmos L=0.13u W=0.3u AS=0.0525p
+ AD=0.331736842105p PS=0.65u PD=2.24315789474u rfmode=0
M$2120 \$2417 \$2372 GND GND sg13_lv_nmos L=0.13u W=0.3u AS=0.0525p
+ AD=0.331736842105p PS=0.65u PD=2.24315789474u rfmode=0
M$2121 \$2419 \$2373 GND GND sg13_lv_nmos L=0.13u W=0.3u AS=0.0525p
+ AD=0.331736842105p PS=0.65u PD=2.24315789474u rfmode=0
M$2122 \$2421 \$2374 GND GND sg13_lv_nmos L=0.13u W=0.3u AS=0.0525p
+ AD=0.331736842105p PS=0.65u PD=2.24315789474u rfmode=0
M$2123 \$2422 \$2375 GND GND sg13_lv_nmos L=0.13u W=0.3u AS=0.0525p
+ AD=0.331736842105p PS=0.65u PD=2.24315789474u rfmode=0
M$2124 \$2424 \$2376 GND GND sg13_lv_nmos L=0.13u W=0.3u AS=0.0525p
+ AD=0.331736842105p PS=0.65u PD=2.24315789474u rfmode=0
M$2125 \$2425 \$2377 GND GND sg13_lv_nmos L=0.13u W=0.3u AS=0.0525p
+ AD=0.331736842105p PS=0.65u PD=2.24315789474u rfmode=0
M$2126 \$2427 \$2378 GND GND sg13_lv_nmos L=0.13u W=0.3u AS=0.0525p
+ AD=0.331736842105p PS=0.65u PD=2.24315789474u rfmode=0
M$2127 \$2429 \$2379 GND GND sg13_lv_nmos L=0.13u W=0.3u AS=0.0525p
+ AD=0.331736842105p PS=0.65u PD=2.24315789474u rfmode=0
M$2128 \$2430 \$2380 GND GND sg13_lv_nmos L=0.13u W=0.3u AS=0.0525p
+ AD=0.331736842105p PS=0.65u PD=2.24315789474u rfmode=0
M$2129 GND \$2296 \$2354 GND sg13_lv_nmos L=0.13u W=0.3u AS=0.331736842105p
+ AD=0.0525p PS=2.24315789474u PD=0.65u rfmode=0
M$2130 GND \$2297 \$2355 GND sg13_lv_nmos L=0.13u W=0.3u AS=0.331736842105p
+ AD=0.0525p PS=2.24315789474u PD=0.65u rfmode=0
M$2131 GND \$2298 \$2357 GND sg13_lv_nmos L=0.13u W=0.3u AS=0.331736842105p
+ AD=0.0525p PS=2.24315789474u PD=0.65u rfmode=0
M$2132 GND \$2299 \$2358 GND sg13_lv_nmos L=0.13u W=0.3u AS=0.331736842105p
+ AD=0.0525p PS=2.24315789474u PD=0.65u rfmode=0
M$2133 GND \$2300 \$2356 GND sg13_lv_nmos L=0.13u W=0.3u AS=0.331736842105p
+ AD=0.0525p PS=2.24315789474u PD=0.65u rfmode=0
M$2134 GND \$2301 \$2353 GND sg13_lv_nmos L=0.13u W=0.3u AS=0.331736842105p
+ AD=0.0525p PS=2.24315789474u PD=0.65u rfmode=0
M$2135 GND \$2302 \$2352 GND sg13_lv_nmos L=0.13u W=0.3u AS=0.331736842105p
+ AD=0.0525p PS=2.24315789474u PD=0.65u rfmode=0
M$2136 GND \$2303 \$2349 GND sg13_lv_nmos L=0.13u W=0.3u AS=0.331736842105p
+ AD=0.0525p PS=2.24315789474u PD=0.65u rfmode=0
M$2137 GND \$2304 \$2346 GND sg13_lv_nmos L=0.13u W=0.3u AS=0.331736842105p
+ AD=0.0525p PS=2.24315789474u PD=0.65u rfmode=0
M$2138 GND \$2305 \$2344 GND sg13_lv_nmos L=0.13u W=0.3u AS=0.331736842105p
+ AD=0.0525p PS=2.24315789474u PD=0.65u rfmode=0
M$2139 GND \$2306 \$2341 GND sg13_lv_nmos L=0.13u W=0.3u AS=0.331736842105p
+ AD=0.0525p PS=2.24315789474u PD=0.65u rfmode=0
M$2140 GND \$2307 \$2339 GND sg13_lv_nmos L=0.13u W=0.3u AS=0.331736842105p
+ AD=0.0525p PS=2.24315789474u PD=0.65u rfmode=0
M$2141 GND \$2308 \$2336 GND sg13_lv_nmos L=0.13u W=0.3u AS=0.331736842105p
+ AD=0.0525p PS=2.24315789474u PD=0.65u rfmode=0
M$2142 GND \$2309 \$2333 GND sg13_lv_nmos L=0.13u W=0.3u AS=0.331736842105p
+ AD=0.0525p PS=2.24315789474u PD=0.65u rfmode=0
M$2143 GND \$2310 \$2331 GND sg13_lv_nmos L=0.13u W=0.3u AS=0.331736842105p
+ AD=0.0525p PS=2.24315789474u PD=0.65u rfmode=0
M$2144 GND \$2311 \$2329 GND sg13_lv_nmos L=0.13u W=0.3u AS=0.331736842105p
+ AD=0.0525p PS=2.24315789474u PD=0.65u rfmode=0
M$2145 GND \$2312 \$2326 GND sg13_lv_nmos L=0.13u W=0.3u AS=0.331736842105p
+ AD=0.0525p PS=2.24315789474u PD=0.65u rfmode=0
M$2146 GND \$2313 \$2323 GND sg13_lv_nmos L=0.13u W=0.3u AS=0.331736842105p
+ AD=0.0525p PS=2.24315789474u PD=0.65u rfmode=0
M$2147 GND \$2314 \$2321 GND sg13_lv_nmos L=0.13u W=0.3u AS=0.331736842105p
+ AD=0.0525p PS=2.24315789474u PD=0.65u rfmode=0
M$2148 \$2354 RWL[27] RBL[19] GND sg13_lv_nmos L=0.13u W=0.3u AS=0.0525p
+ AD=0.057p PS=0.65u PD=0.68u rfmode=0
M$2149 \$2355 RWL[27] RBL[20] GND sg13_lv_nmos L=0.13u W=0.3u AS=0.0525p
+ AD=0.057p PS=0.65u PD=0.68u rfmode=0
M$2150 \$2357 RWL[27] RBL[21] GND sg13_lv_nmos L=0.13u W=0.3u AS=0.0525p
+ AD=0.057p PS=0.65u PD=0.68u rfmode=0
M$2151 \$2358 RWL[27] RBL[22] GND sg13_lv_nmos L=0.13u W=0.3u AS=0.0525p
+ AD=0.057p PS=0.65u PD=0.68u rfmode=0
M$2152 \$2356 RWL[27] RBL[23] GND sg13_lv_nmos L=0.13u W=0.3u AS=0.0525p
+ AD=0.057p PS=0.65u PD=0.68u rfmode=0
M$2153 \$2353 RWL[27] RBL[24] GND sg13_lv_nmos L=0.13u W=0.3u AS=0.0525p
+ AD=0.057p PS=0.65u PD=0.68u rfmode=0
M$2154 \$2352 RWL[27] RBL[25] GND sg13_lv_nmos L=0.13u W=0.3u AS=0.0525p
+ AD=0.057p PS=0.65u PD=0.68u rfmode=0
M$2155 \$2349 RWL[27] RBL[26] GND sg13_lv_nmos L=0.13u W=0.3u AS=0.0525p
+ AD=0.057p PS=0.65u PD=0.68u rfmode=0
M$2156 \$2346 RWL[27] RBL[27] GND sg13_lv_nmos L=0.13u W=0.3u AS=0.0525p
+ AD=0.057p PS=0.65u PD=0.68u rfmode=0
M$2157 \$2344 RWL[27] RBL[28] GND sg13_lv_nmos L=0.13u W=0.3u AS=0.0525p
+ AD=0.057p PS=0.65u PD=0.68u rfmode=0
M$2158 \$2341 RWL[27] RBL[29] GND sg13_lv_nmos L=0.13u W=0.3u AS=0.0525p
+ AD=0.057p PS=0.65u PD=0.68u rfmode=0
M$2159 \$2339 RWL[27] RBL[30] GND sg13_lv_nmos L=0.13u W=0.3u AS=0.0525p
+ AD=0.057p PS=0.65u PD=0.68u rfmode=0
M$2160 \$2336 RWL[27] RBL[31] GND sg13_lv_nmos L=0.13u W=0.3u AS=0.0525p
+ AD=0.057p PS=0.65u PD=0.68u rfmode=0
M$2161 \$2333 RWL[27] RBL[32] GND sg13_lv_nmos L=0.13u W=0.3u AS=0.0525p
+ AD=0.057p PS=0.65u PD=0.68u rfmode=0
M$2162 \$2331 RWL[27] RBL[33] GND sg13_lv_nmos L=0.13u W=0.3u AS=0.0525p
+ AD=0.057p PS=0.65u PD=0.68u rfmode=0
M$2163 \$2329 RWL[27] RBL[34] GND sg13_lv_nmos L=0.13u W=0.3u AS=0.0525p
+ AD=0.057p PS=0.65u PD=0.68u rfmode=0
M$2164 \$2326 RWL[27] RBL[35] GND sg13_lv_nmos L=0.13u W=0.3u AS=0.0525p
+ AD=0.057p PS=0.65u PD=0.68u rfmode=0
M$2165 \$2323 RWL[27] RBL[36] GND sg13_lv_nmos L=0.13u W=0.3u AS=0.0525p
+ AD=0.057p PS=0.65u PD=0.68u rfmode=0
M$2166 \$2321 RWL[27] RBL[37] GND sg13_lv_nmos L=0.13u W=0.3u AS=0.0525p
+ AD=0.057p PS=0.65u PD=0.68u rfmode=0
M$2167 RBL[19] RWL[28] \$2433 GND sg13_lv_nmos L=0.13u W=0.3u AS=0.057p
+ AD=0.0525p PS=0.68u PD=0.65u rfmode=0
M$2168 RBL[20] RWL[28] \$2434 GND sg13_lv_nmos L=0.13u W=0.3u AS=0.057p
+ AD=0.0525p PS=0.68u PD=0.65u rfmode=0
M$2169 RBL[21] RWL[28] \$2436 GND sg13_lv_nmos L=0.13u W=0.3u AS=0.057p
+ AD=0.0525p PS=0.68u PD=0.65u rfmode=0
M$2170 RBL[22] RWL[28] \$2438 GND sg13_lv_nmos L=0.13u W=0.3u AS=0.057p
+ AD=0.0525p PS=0.68u PD=0.65u rfmode=0
M$2171 RBL[23] RWL[28] \$2439 GND sg13_lv_nmos L=0.13u W=0.3u AS=0.057p
+ AD=0.0525p PS=0.68u PD=0.65u rfmode=0
M$2172 RBL[24] RWL[28] \$2437 GND sg13_lv_nmos L=0.13u W=0.3u AS=0.057p
+ AD=0.0525p PS=0.68u PD=0.65u rfmode=0
M$2173 RBL[25] RWL[28] \$2435 GND sg13_lv_nmos L=0.13u W=0.3u AS=0.057p
+ AD=0.0525p PS=0.68u PD=0.65u rfmode=0
M$2174 RBL[26] RWL[28] \$2432 GND sg13_lv_nmos L=0.13u W=0.3u AS=0.057p
+ AD=0.0525p PS=0.68u PD=0.65u rfmode=0
M$2175 RBL[27] RWL[28] \$2431 GND sg13_lv_nmos L=0.13u W=0.3u AS=0.057p
+ AD=0.0525p PS=0.68u PD=0.65u rfmode=0
M$2176 RBL[28] RWL[28] \$2428 GND sg13_lv_nmos L=0.13u W=0.3u AS=0.057p
+ AD=0.0525p PS=0.68u PD=0.65u rfmode=0
M$2177 RBL[29] RWL[28] \$2426 GND sg13_lv_nmos L=0.13u W=0.3u AS=0.057p
+ AD=0.0525p PS=0.68u PD=0.65u rfmode=0
M$2178 RBL[30] RWL[28] \$2423 GND sg13_lv_nmos L=0.13u W=0.3u AS=0.057p
+ AD=0.0525p PS=0.68u PD=0.65u rfmode=0
M$2179 RBL[31] RWL[28] \$2420 GND sg13_lv_nmos L=0.13u W=0.3u AS=0.057p
+ AD=0.0525p PS=0.68u PD=0.65u rfmode=0
M$2180 RBL[32] RWL[28] \$2418 GND sg13_lv_nmos L=0.13u W=0.3u AS=0.057p
+ AD=0.0525p PS=0.68u PD=0.65u rfmode=0
M$2181 RBL[33] RWL[28] \$2415 GND sg13_lv_nmos L=0.13u W=0.3u AS=0.057p
+ AD=0.0525p PS=0.68u PD=0.65u rfmode=0
M$2182 RBL[34] RWL[28] \$2413 GND sg13_lv_nmos L=0.13u W=0.3u AS=0.057p
+ AD=0.0525p PS=0.68u PD=0.65u rfmode=0
M$2183 RBL[35] RWL[28] \$2410 GND sg13_lv_nmos L=0.13u W=0.3u AS=0.057p
+ AD=0.0525p PS=0.68u PD=0.65u rfmode=0
M$2184 RBL[36] RWL[28] \$2408 GND sg13_lv_nmos L=0.13u W=0.3u AS=0.057p
+ AD=0.0525p PS=0.68u PD=0.65u rfmode=0
M$2185 RBL[37] RWL[28] \$2405 GND sg13_lv_nmos L=0.13u W=0.3u AS=0.057p
+ AD=0.0525p PS=0.68u PD=0.65u rfmode=0
M$2186 \$2433 \$2381 GND GND sg13_lv_nmos L=0.13u W=0.3u AS=0.0525p
+ AD=0.331736842105p PS=0.65u PD=2.24315789474u rfmode=0
M$2187 \$2434 \$2382 GND GND sg13_lv_nmos L=0.13u W=0.3u AS=0.0525p
+ AD=0.331736842105p PS=0.65u PD=2.24315789474u rfmode=0
M$2188 \$2436 \$2383 GND GND sg13_lv_nmos L=0.13u W=0.3u AS=0.0525p
+ AD=0.331736842105p PS=0.65u PD=2.24315789474u rfmode=0
M$2189 \$2438 \$2384 GND GND sg13_lv_nmos L=0.13u W=0.3u AS=0.0525p
+ AD=0.331736842105p PS=0.65u PD=2.24315789474u rfmode=0
M$2190 \$2439 \$2385 GND GND sg13_lv_nmos L=0.13u W=0.3u AS=0.0525p
+ AD=0.331736842105p PS=0.65u PD=2.24315789474u rfmode=0
M$2191 \$2437 \$2386 GND GND sg13_lv_nmos L=0.13u W=0.3u AS=0.0525p
+ AD=0.331736842105p PS=0.65u PD=2.24315789474u rfmode=0
M$2192 \$2435 \$2387 GND GND sg13_lv_nmos L=0.13u W=0.3u AS=0.0525p
+ AD=0.331736842105p PS=0.65u PD=2.24315789474u rfmode=0
M$2193 \$2432 \$2388 GND GND sg13_lv_nmos L=0.13u W=0.3u AS=0.0525p
+ AD=0.331736842105p PS=0.65u PD=2.24315789474u rfmode=0
M$2194 \$2431 \$2389 GND GND sg13_lv_nmos L=0.13u W=0.3u AS=0.0525p
+ AD=0.331736842105p PS=0.65u PD=2.24315789474u rfmode=0
M$2195 \$2428 \$2390 GND GND sg13_lv_nmos L=0.13u W=0.3u AS=0.0525p
+ AD=0.331736842105p PS=0.65u PD=2.24315789474u rfmode=0
M$2196 \$2426 \$2391 GND GND sg13_lv_nmos L=0.13u W=0.3u AS=0.0525p
+ AD=0.331736842105p PS=0.65u PD=2.24315789474u rfmode=0
M$2197 \$2423 \$2392 GND GND sg13_lv_nmos L=0.13u W=0.3u AS=0.0525p
+ AD=0.331736842105p PS=0.65u PD=2.24315789474u rfmode=0
M$2198 \$2420 \$2393 GND GND sg13_lv_nmos L=0.13u W=0.3u AS=0.0525p
+ AD=0.331736842105p PS=0.65u PD=2.24315789474u rfmode=0
M$2199 \$2418 \$2394 GND GND sg13_lv_nmos L=0.13u W=0.3u AS=0.0525p
+ AD=0.331736842105p PS=0.65u PD=2.24315789474u rfmode=0
M$2200 \$2415 \$2395 GND GND sg13_lv_nmos L=0.13u W=0.3u AS=0.0525p
+ AD=0.331736842105p PS=0.65u PD=2.24315789474u rfmode=0
M$2201 \$2413 \$2396 GND GND sg13_lv_nmos L=0.13u W=0.3u AS=0.0525p
+ AD=0.331736842105p PS=0.65u PD=2.24315789474u rfmode=0
M$2202 \$2410 \$2397 GND GND sg13_lv_nmos L=0.13u W=0.3u AS=0.0525p
+ AD=0.331736842105p PS=0.65u PD=2.24315789474u rfmode=0
M$2203 \$2408 \$2398 GND GND sg13_lv_nmos L=0.13u W=0.3u AS=0.0525p
+ AD=0.331736842105p PS=0.65u PD=2.24315789474u rfmode=0
M$2204 \$2405 \$2399 GND GND sg13_lv_nmos L=0.13u W=0.3u AS=0.0525p
+ AD=0.331736842105p PS=0.65u PD=2.24315789474u rfmode=0
M$2205 GND \$2440 \$2485 GND sg13_lv_nmos L=0.13u W=0.3u AS=0.331736842105p
+ AD=0.0525p PS=2.24315789474u PD=0.65u rfmode=0
M$2206 GND \$2441 \$2487 GND sg13_lv_nmos L=0.13u W=0.3u AS=0.331736842105p
+ AD=0.0525p PS=2.24315789474u PD=0.65u rfmode=0
M$2207 GND \$2442 \$2488 GND sg13_lv_nmos L=0.13u W=0.3u AS=0.331736842105p
+ AD=0.0525p PS=2.24315789474u PD=0.65u rfmode=0
M$2208 GND \$2443 \$2490 GND sg13_lv_nmos L=0.13u W=0.3u AS=0.331736842105p
+ AD=0.0525p PS=2.24315789474u PD=0.65u rfmode=0
M$2209 GND \$2444 \$2491 GND sg13_lv_nmos L=0.13u W=0.3u AS=0.331736842105p
+ AD=0.0525p PS=2.24315789474u PD=0.65u rfmode=0
M$2210 GND \$2445 \$2493 GND sg13_lv_nmos L=0.13u W=0.3u AS=0.331736842105p
+ AD=0.0525p PS=2.24315789474u PD=0.65u rfmode=0
M$2211 GND \$2446 \$2495 GND sg13_lv_nmos L=0.13u W=0.3u AS=0.331736842105p
+ AD=0.0525p PS=2.24315789474u PD=0.65u rfmode=0
M$2212 GND \$2447 \$2497 GND sg13_lv_nmos L=0.13u W=0.3u AS=0.331736842105p
+ AD=0.0525p PS=2.24315789474u PD=0.65u rfmode=0
M$2213 GND \$2448 \$2498 GND sg13_lv_nmos L=0.13u W=0.3u AS=0.331736842105p
+ AD=0.0525p PS=2.24315789474u PD=0.65u rfmode=0
M$2214 GND \$2449 \$2500 GND sg13_lv_nmos L=0.13u W=0.3u AS=0.331736842105p
+ AD=0.0525p PS=2.24315789474u PD=0.65u rfmode=0
M$2215 GND \$2450 \$2502 GND sg13_lv_nmos L=0.13u W=0.3u AS=0.331736842105p
+ AD=0.0525p PS=2.24315789474u PD=0.65u rfmode=0
M$2216 GND \$2451 \$2503 GND sg13_lv_nmos L=0.13u W=0.3u AS=0.331736842105p
+ AD=0.0525p PS=2.24315789474u PD=0.65u rfmode=0
M$2217 GND \$2452 \$2505 GND sg13_lv_nmos L=0.13u W=0.3u AS=0.331736842105p
+ AD=0.0525p PS=2.24315789474u PD=0.65u rfmode=0
M$2218 GND \$2453 \$2506 GND sg13_lv_nmos L=0.13u W=0.3u AS=0.331736842105p
+ AD=0.0525p PS=2.24315789474u PD=0.65u rfmode=0
M$2219 GND \$2454 \$2508 GND sg13_lv_nmos L=0.13u W=0.3u AS=0.331736842105p
+ AD=0.0525p PS=2.24315789474u PD=0.65u rfmode=0
M$2220 GND \$2455 \$2510 GND sg13_lv_nmos L=0.13u W=0.3u AS=0.331736842105p
+ AD=0.0525p PS=2.24315789474u PD=0.65u rfmode=0
M$2221 GND \$2456 \$2511 GND sg13_lv_nmos L=0.13u W=0.3u AS=0.331736842105p
+ AD=0.0525p PS=2.24315789474u PD=0.65u rfmode=0
M$2222 GND \$2457 \$2513 GND sg13_lv_nmos L=0.13u W=0.3u AS=0.331736842105p
+ AD=0.0525p PS=2.24315789474u PD=0.65u rfmode=0
M$2223 GND \$2458 \$2514 GND sg13_lv_nmos L=0.13u W=0.3u AS=0.331736842105p
+ AD=0.0525p PS=2.24315789474u PD=0.65u rfmode=0
M$2224 \$2485 RWL[29] RBL[0] GND sg13_lv_nmos L=0.13u W=0.3u AS=0.0525p
+ AD=0.057p PS=0.65u PD=0.68u rfmode=0
M$2225 \$2487 RWL[29] RBL[1] GND sg13_lv_nmos L=0.13u W=0.3u AS=0.0525p
+ AD=0.057p PS=0.65u PD=0.68u rfmode=0
M$2226 \$2488 RWL[29] RBL[2] GND sg13_lv_nmos L=0.13u W=0.3u AS=0.0525p
+ AD=0.057p PS=0.65u PD=0.68u rfmode=0
M$2227 \$2490 RWL[29] RBL[3] GND sg13_lv_nmos L=0.13u W=0.3u AS=0.0525p
+ AD=0.057p PS=0.65u PD=0.68u rfmode=0
M$2228 \$2491 RWL[29] RBL[4] GND sg13_lv_nmos L=0.13u W=0.3u AS=0.0525p
+ AD=0.057p PS=0.65u PD=0.68u rfmode=0
M$2229 \$2493 RWL[29] RBL[5] GND sg13_lv_nmos L=0.13u W=0.3u AS=0.0525p
+ AD=0.057p PS=0.65u PD=0.68u rfmode=0
M$2230 \$2495 RWL[29] RBL[6] GND sg13_lv_nmos L=0.13u W=0.3u AS=0.0525p
+ AD=0.057p PS=0.65u PD=0.68u rfmode=0
M$2231 \$2497 RWL[29] RBL[7] GND sg13_lv_nmos L=0.13u W=0.3u AS=0.0525p
+ AD=0.057p PS=0.65u PD=0.68u rfmode=0
M$2232 \$2498 RWL[29] RBL[8] GND sg13_lv_nmos L=0.13u W=0.3u AS=0.0525p
+ AD=0.057p PS=0.65u PD=0.68u rfmode=0
M$2233 \$2500 RWL[29] RBL[9] GND sg13_lv_nmos L=0.13u W=0.3u AS=0.0525p
+ AD=0.057p PS=0.65u PD=0.68u rfmode=0
M$2234 \$2502 RWL[29] RBL[10] GND sg13_lv_nmos L=0.13u W=0.3u AS=0.0525p
+ AD=0.057p PS=0.65u PD=0.68u rfmode=0
M$2235 \$2503 RWL[29] RBL[11] GND sg13_lv_nmos L=0.13u W=0.3u AS=0.0525p
+ AD=0.057p PS=0.65u PD=0.68u rfmode=0
M$2236 \$2505 RWL[29] RBL[12] GND sg13_lv_nmos L=0.13u W=0.3u AS=0.0525p
+ AD=0.057p PS=0.65u PD=0.68u rfmode=0
M$2237 \$2506 RWL[29] RBL[13] GND sg13_lv_nmos L=0.13u W=0.3u AS=0.0525p
+ AD=0.057p PS=0.65u PD=0.68u rfmode=0
M$2238 \$2508 RWL[29] RBL[14] GND sg13_lv_nmos L=0.13u W=0.3u AS=0.0525p
+ AD=0.057p PS=0.65u PD=0.68u rfmode=0
M$2239 \$2510 RWL[29] RBL[15] GND sg13_lv_nmos L=0.13u W=0.3u AS=0.0525p
+ AD=0.057p PS=0.65u PD=0.68u rfmode=0
M$2240 \$2511 RWL[29] RBL[16] GND sg13_lv_nmos L=0.13u W=0.3u AS=0.0525p
+ AD=0.057p PS=0.65u PD=0.68u rfmode=0
M$2241 \$2513 RWL[29] RBL[17] GND sg13_lv_nmos L=0.13u W=0.3u AS=0.0525p
+ AD=0.057p PS=0.65u PD=0.68u rfmode=0
M$2242 \$2514 RWL[29] RBL[18] GND sg13_lv_nmos L=0.13u W=0.3u AS=0.0525p
+ AD=0.057p PS=0.65u PD=0.68u rfmode=0
M$2243 RBL[0] RWL[30] \$2565 GND sg13_lv_nmos L=0.13u W=0.3u AS=0.057p
+ AD=0.0525p PS=0.68u PD=0.65u rfmode=0
M$2244 RBL[1] RWL[30] \$2566 GND sg13_lv_nmos L=0.13u W=0.3u AS=0.057p
+ AD=0.0525p PS=0.68u PD=0.65u rfmode=0
M$2245 RBL[2] RWL[30] \$2568 GND sg13_lv_nmos L=0.13u W=0.3u AS=0.057p
+ AD=0.0525p PS=0.68u PD=0.65u rfmode=0
M$2246 RBL[3] RWL[30] \$2569 GND sg13_lv_nmos L=0.13u W=0.3u AS=0.057p
+ AD=0.0525p PS=0.68u PD=0.65u rfmode=0
M$2247 RBL[4] RWL[30] \$2571 GND sg13_lv_nmos L=0.13u W=0.3u AS=0.057p
+ AD=0.0525p PS=0.68u PD=0.65u rfmode=0
M$2248 RBL[5] RWL[30] \$2572 GND sg13_lv_nmos L=0.13u W=0.3u AS=0.057p
+ AD=0.0525p PS=0.68u PD=0.65u rfmode=0
M$2249 RBL[6] RWL[30] \$2574 GND sg13_lv_nmos L=0.13u W=0.3u AS=0.057p
+ AD=0.0525p PS=0.68u PD=0.65u rfmode=0
M$2250 RBL[7] RWL[30] \$2575 GND sg13_lv_nmos L=0.13u W=0.3u AS=0.057p
+ AD=0.0525p PS=0.68u PD=0.65u rfmode=0
M$2251 RBL[8] RWL[30] \$2577 GND sg13_lv_nmos L=0.13u W=0.3u AS=0.057p
+ AD=0.0525p PS=0.68u PD=0.65u rfmode=0
M$2252 RBL[9] RWL[30] \$2579 GND sg13_lv_nmos L=0.13u W=0.3u AS=0.057p
+ AD=0.0525p PS=0.68u PD=0.65u rfmode=0
M$2253 RBL[10] RWL[30] \$2580 GND sg13_lv_nmos L=0.13u W=0.3u AS=0.057p
+ AD=0.0525p PS=0.68u PD=0.65u rfmode=0
M$2254 RBL[11] RWL[30] \$2582 GND sg13_lv_nmos L=0.13u W=0.3u AS=0.057p
+ AD=0.0525p PS=0.68u PD=0.65u rfmode=0
M$2255 RBL[12] RWL[30] \$2584 GND sg13_lv_nmos L=0.13u W=0.3u AS=0.057p
+ AD=0.0525p PS=0.68u PD=0.65u rfmode=0
M$2256 RBL[13] RWL[30] \$2585 GND sg13_lv_nmos L=0.13u W=0.3u AS=0.057p
+ AD=0.0525p PS=0.68u PD=0.65u rfmode=0
M$2257 RBL[14] RWL[30] \$2587 GND sg13_lv_nmos L=0.13u W=0.3u AS=0.057p
+ AD=0.0525p PS=0.68u PD=0.65u rfmode=0
M$2258 RBL[15] RWL[30] \$2588 GND sg13_lv_nmos L=0.13u W=0.3u AS=0.057p
+ AD=0.0525p PS=0.68u PD=0.65u rfmode=0
M$2259 RBL[16] RWL[30] \$2590 GND sg13_lv_nmos L=0.13u W=0.3u AS=0.057p
+ AD=0.0525p PS=0.68u PD=0.65u rfmode=0
M$2260 RBL[17] RWL[30] \$2592 GND sg13_lv_nmos L=0.13u W=0.3u AS=0.057p
+ AD=0.0525p PS=0.68u PD=0.65u rfmode=0
M$2261 RBL[18] RWL[30] \$2593 GND sg13_lv_nmos L=0.13u W=0.3u AS=0.057p
+ AD=0.0525p PS=0.68u PD=0.65u rfmode=0
M$2262 \$2565 \$2525 GND GND sg13_lv_nmos L=0.13u W=0.3u AS=0.0525p
+ AD=0.331736842105p PS=0.65u PD=2.24315789474u rfmode=0
M$2263 \$2566 \$2526 GND GND sg13_lv_nmos L=0.13u W=0.3u AS=0.0525p
+ AD=0.331736842105p PS=0.65u PD=2.24315789474u rfmode=0
M$2264 \$2568 \$2527 GND GND sg13_lv_nmos L=0.13u W=0.3u AS=0.0525p
+ AD=0.331736842105p PS=0.65u PD=2.24315789474u rfmode=0
M$2265 \$2569 \$2528 GND GND sg13_lv_nmos L=0.13u W=0.3u AS=0.0525p
+ AD=0.331736842105p PS=0.65u PD=2.24315789474u rfmode=0
M$2266 \$2571 \$2529 GND GND sg13_lv_nmos L=0.13u W=0.3u AS=0.0525p
+ AD=0.331736842105p PS=0.65u PD=2.24315789474u rfmode=0
M$2267 \$2572 \$2530 GND GND sg13_lv_nmos L=0.13u W=0.3u AS=0.0525p
+ AD=0.331736842105p PS=0.65u PD=2.24315789474u rfmode=0
M$2268 \$2574 \$2531 GND GND sg13_lv_nmos L=0.13u W=0.3u AS=0.0525p
+ AD=0.331736842105p PS=0.65u PD=2.24315789474u rfmode=0
M$2269 \$2575 \$2532 GND GND sg13_lv_nmos L=0.13u W=0.3u AS=0.0525p
+ AD=0.331736842105p PS=0.65u PD=2.24315789474u rfmode=0
M$2270 \$2577 \$2533 GND GND sg13_lv_nmos L=0.13u W=0.3u AS=0.0525p
+ AD=0.331736842105p PS=0.65u PD=2.24315789474u rfmode=0
M$2271 \$2579 \$2534 GND GND sg13_lv_nmos L=0.13u W=0.3u AS=0.0525p
+ AD=0.331736842105p PS=0.65u PD=2.24315789474u rfmode=0
M$2272 \$2580 \$2535 GND GND sg13_lv_nmos L=0.13u W=0.3u AS=0.0525p
+ AD=0.331736842105p PS=0.65u PD=2.24315789474u rfmode=0
M$2273 \$2582 \$2536 GND GND sg13_lv_nmos L=0.13u W=0.3u AS=0.0525p
+ AD=0.331736842105p PS=0.65u PD=2.24315789474u rfmode=0
M$2274 \$2584 \$2537 GND GND sg13_lv_nmos L=0.13u W=0.3u AS=0.0525p
+ AD=0.331736842105p PS=0.65u PD=2.24315789474u rfmode=0
M$2275 \$2585 \$2538 GND GND sg13_lv_nmos L=0.13u W=0.3u AS=0.0525p
+ AD=0.331736842105p PS=0.65u PD=2.24315789474u rfmode=0
M$2276 \$2587 \$2539 GND GND sg13_lv_nmos L=0.13u W=0.3u AS=0.0525p
+ AD=0.331736842105p PS=0.65u PD=2.24315789474u rfmode=0
M$2277 \$2588 \$2540 GND GND sg13_lv_nmos L=0.13u W=0.3u AS=0.0525p
+ AD=0.331736842105p PS=0.65u PD=2.24315789474u rfmode=0
M$2278 \$2590 \$2541 GND GND sg13_lv_nmos L=0.13u W=0.3u AS=0.0525p
+ AD=0.331736842105p PS=0.65u PD=2.24315789474u rfmode=0
M$2279 \$2592 \$2542 GND GND sg13_lv_nmos L=0.13u W=0.3u AS=0.0525p
+ AD=0.331736842105p PS=0.65u PD=2.24315789474u rfmode=0
M$2280 \$2593 \$2543 GND GND sg13_lv_nmos L=0.13u W=0.3u AS=0.0525p
+ AD=0.331736842105p PS=0.65u PD=2.24315789474u rfmode=0
M$2281 GND \$2459 \$2516 GND sg13_lv_nmos L=0.13u W=0.3u AS=0.331736842105p
+ AD=0.0525p PS=2.24315789474u PD=0.65u rfmode=0
M$2282 GND \$2460 \$2518 GND sg13_lv_nmos L=0.13u W=0.3u AS=0.331736842105p
+ AD=0.0525p PS=2.24315789474u PD=0.65u rfmode=0
M$2283 GND \$2461 \$2520 GND sg13_lv_nmos L=0.13u W=0.3u AS=0.331736842105p
+ AD=0.0525p PS=2.24315789474u PD=0.65u rfmode=0
M$2284 GND \$2462 \$2521 GND sg13_lv_nmos L=0.13u W=0.3u AS=0.331736842105p
+ AD=0.0525p PS=2.24315789474u PD=0.65u rfmode=0
M$2285 GND \$2463 \$2519 GND sg13_lv_nmos L=0.13u W=0.3u AS=0.331736842105p
+ AD=0.0525p PS=2.24315789474u PD=0.65u rfmode=0
M$2286 GND \$2464 \$2517 GND sg13_lv_nmos L=0.13u W=0.3u AS=0.331736842105p
+ AD=0.0525p PS=2.24315789474u PD=0.65u rfmode=0
M$2287 GND \$2465 \$2515 GND sg13_lv_nmos L=0.13u W=0.3u AS=0.331736842105p
+ AD=0.0525p PS=2.24315789474u PD=0.65u rfmode=0
M$2288 GND \$2466 \$2512 GND sg13_lv_nmos L=0.13u W=0.3u AS=0.331736842105p
+ AD=0.0525p PS=2.24315789474u PD=0.65u rfmode=0
M$2289 GND \$2467 \$2509 GND sg13_lv_nmos L=0.13u W=0.3u AS=0.331736842105p
+ AD=0.0525p PS=2.24315789474u PD=0.65u rfmode=0
M$2290 GND \$2468 \$2507 GND sg13_lv_nmos L=0.13u W=0.3u AS=0.331736842105p
+ AD=0.0525p PS=2.24315789474u PD=0.65u rfmode=0
M$2291 GND \$2469 \$2504 GND sg13_lv_nmos L=0.13u W=0.3u AS=0.331736842105p
+ AD=0.0525p PS=2.24315789474u PD=0.65u rfmode=0
M$2292 GND \$2470 \$2501 GND sg13_lv_nmos L=0.13u W=0.3u AS=0.331736842105p
+ AD=0.0525p PS=2.24315789474u PD=0.65u rfmode=0
M$2293 GND \$2471 \$2499 GND sg13_lv_nmos L=0.13u W=0.3u AS=0.331736842105p
+ AD=0.0525p PS=2.24315789474u PD=0.65u rfmode=0
M$2294 GND \$2472 \$2496 GND sg13_lv_nmos L=0.13u W=0.3u AS=0.331736842105p
+ AD=0.0525p PS=2.24315789474u PD=0.65u rfmode=0
M$2295 GND \$2473 \$2494 GND sg13_lv_nmos L=0.13u W=0.3u AS=0.331736842105p
+ AD=0.0525p PS=2.24315789474u PD=0.65u rfmode=0
M$2296 GND \$2474 \$2492 GND sg13_lv_nmos L=0.13u W=0.3u AS=0.331736842105p
+ AD=0.0525p PS=2.24315789474u PD=0.65u rfmode=0
M$2297 GND \$2475 \$2489 GND sg13_lv_nmos L=0.13u W=0.3u AS=0.331736842105p
+ AD=0.0525p PS=2.24315789474u PD=0.65u rfmode=0
M$2298 GND \$2476 \$2486 GND sg13_lv_nmos L=0.13u W=0.3u AS=0.331736842105p
+ AD=0.0525p PS=2.24315789474u PD=0.65u rfmode=0
M$2299 GND \$2477 \$2484 GND sg13_lv_nmos L=0.13u W=0.3u AS=0.331736842105p
+ AD=0.0525p PS=2.24315789474u PD=0.65u rfmode=0
M$2300 \$2516 RWL[29] RBL[19] GND sg13_lv_nmos L=0.13u W=0.3u AS=0.0525p
+ AD=0.057p PS=0.65u PD=0.68u rfmode=0
M$2301 \$2518 RWL[29] RBL[20] GND sg13_lv_nmos L=0.13u W=0.3u AS=0.0525p
+ AD=0.057p PS=0.65u PD=0.68u rfmode=0
M$2302 \$2520 RWL[29] RBL[21] GND sg13_lv_nmos L=0.13u W=0.3u AS=0.0525p
+ AD=0.057p PS=0.65u PD=0.68u rfmode=0
M$2303 \$2521 RWL[29] RBL[22] GND sg13_lv_nmos L=0.13u W=0.3u AS=0.0525p
+ AD=0.057p PS=0.65u PD=0.68u rfmode=0
M$2304 \$2519 RWL[29] RBL[23] GND sg13_lv_nmos L=0.13u W=0.3u AS=0.0525p
+ AD=0.057p PS=0.65u PD=0.68u rfmode=0
M$2305 \$2517 RWL[29] RBL[24] GND sg13_lv_nmos L=0.13u W=0.3u AS=0.0525p
+ AD=0.057p PS=0.65u PD=0.68u rfmode=0
M$2306 \$2515 RWL[29] RBL[25] GND sg13_lv_nmos L=0.13u W=0.3u AS=0.0525p
+ AD=0.057p PS=0.65u PD=0.68u rfmode=0
M$2307 \$2512 RWL[29] RBL[26] GND sg13_lv_nmos L=0.13u W=0.3u AS=0.0525p
+ AD=0.057p PS=0.65u PD=0.68u rfmode=0
M$2308 \$2509 RWL[29] RBL[27] GND sg13_lv_nmos L=0.13u W=0.3u AS=0.0525p
+ AD=0.057p PS=0.65u PD=0.68u rfmode=0
M$2309 \$2507 RWL[29] RBL[28] GND sg13_lv_nmos L=0.13u W=0.3u AS=0.0525p
+ AD=0.057p PS=0.65u PD=0.68u rfmode=0
M$2310 \$2504 RWL[29] RBL[29] GND sg13_lv_nmos L=0.13u W=0.3u AS=0.0525p
+ AD=0.057p PS=0.65u PD=0.68u rfmode=0
M$2311 \$2501 RWL[29] RBL[30] GND sg13_lv_nmos L=0.13u W=0.3u AS=0.0525p
+ AD=0.057p PS=0.65u PD=0.68u rfmode=0
M$2312 \$2499 RWL[29] RBL[31] GND sg13_lv_nmos L=0.13u W=0.3u AS=0.0525p
+ AD=0.057p PS=0.65u PD=0.68u rfmode=0
M$2313 \$2496 RWL[29] RBL[32] GND sg13_lv_nmos L=0.13u W=0.3u AS=0.0525p
+ AD=0.057p PS=0.65u PD=0.68u rfmode=0
M$2314 \$2494 RWL[29] RBL[33] GND sg13_lv_nmos L=0.13u W=0.3u AS=0.0525p
+ AD=0.057p PS=0.65u PD=0.68u rfmode=0
M$2315 \$2492 RWL[29] RBL[34] GND sg13_lv_nmos L=0.13u W=0.3u AS=0.0525p
+ AD=0.057p PS=0.65u PD=0.68u rfmode=0
M$2316 \$2489 RWL[29] RBL[35] GND sg13_lv_nmos L=0.13u W=0.3u AS=0.0525p
+ AD=0.057p PS=0.65u PD=0.68u rfmode=0
M$2317 \$2486 RWL[29] RBL[36] GND sg13_lv_nmos L=0.13u W=0.3u AS=0.0525p
+ AD=0.057p PS=0.65u PD=0.68u rfmode=0
M$2318 \$2484 RWL[29] RBL[37] GND sg13_lv_nmos L=0.13u W=0.3u AS=0.0525p
+ AD=0.057p PS=0.65u PD=0.68u rfmode=0
M$2319 RBL[19] RWL[30] \$2596 GND sg13_lv_nmos L=0.13u W=0.3u AS=0.057p
+ AD=0.0525p PS=0.68u PD=0.65u rfmode=0
M$2320 RBL[20] RWL[30] \$2597 GND sg13_lv_nmos L=0.13u W=0.3u AS=0.057p
+ AD=0.0525p PS=0.68u PD=0.65u rfmode=0
M$2321 RBL[21] RWL[30] \$2599 GND sg13_lv_nmos L=0.13u W=0.3u AS=0.057p
+ AD=0.0525p PS=0.68u PD=0.65u rfmode=0
M$2322 RBL[22] RWL[30] \$2601 GND sg13_lv_nmos L=0.13u W=0.3u AS=0.057p
+ AD=0.0525p PS=0.68u PD=0.65u rfmode=0
M$2323 RBL[23] RWL[30] \$2602 GND sg13_lv_nmos L=0.13u W=0.3u AS=0.057p
+ AD=0.0525p PS=0.68u PD=0.65u rfmode=0
M$2324 RBL[24] RWL[30] \$2600 GND sg13_lv_nmos L=0.13u W=0.3u AS=0.057p
+ AD=0.0525p PS=0.68u PD=0.65u rfmode=0
M$2325 RBL[25] RWL[30] \$2598 GND sg13_lv_nmos L=0.13u W=0.3u AS=0.057p
+ AD=0.0525p PS=0.68u PD=0.65u rfmode=0
M$2326 RBL[26] RWL[30] \$2595 GND sg13_lv_nmos L=0.13u W=0.3u AS=0.057p
+ AD=0.0525p PS=0.68u PD=0.65u rfmode=0
M$2327 RBL[27] RWL[30] \$2594 GND sg13_lv_nmos L=0.13u W=0.3u AS=0.057p
+ AD=0.0525p PS=0.68u PD=0.65u rfmode=0
M$2328 RBL[28] RWL[30] \$2591 GND sg13_lv_nmos L=0.13u W=0.3u AS=0.057p
+ AD=0.0525p PS=0.68u PD=0.65u rfmode=0
M$2329 RBL[29] RWL[30] \$2589 GND sg13_lv_nmos L=0.13u W=0.3u AS=0.057p
+ AD=0.0525p PS=0.68u PD=0.65u rfmode=0
M$2330 RBL[30] RWL[30] \$2586 GND sg13_lv_nmos L=0.13u W=0.3u AS=0.057p
+ AD=0.0525p PS=0.68u PD=0.65u rfmode=0
M$2331 RBL[31] RWL[30] \$2583 GND sg13_lv_nmos L=0.13u W=0.3u AS=0.057p
+ AD=0.0525p PS=0.68u PD=0.65u rfmode=0
M$2332 RBL[32] RWL[30] \$2581 GND sg13_lv_nmos L=0.13u W=0.3u AS=0.057p
+ AD=0.0525p PS=0.68u PD=0.65u rfmode=0
M$2333 RBL[33] RWL[30] \$2578 GND sg13_lv_nmos L=0.13u W=0.3u AS=0.057p
+ AD=0.0525p PS=0.68u PD=0.65u rfmode=0
M$2334 RBL[34] RWL[30] \$2576 GND sg13_lv_nmos L=0.13u W=0.3u AS=0.057p
+ AD=0.0525p PS=0.68u PD=0.65u rfmode=0
M$2335 RBL[35] RWL[30] \$2573 GND sg13_lv_nmos L=0.13u W=0.3u AS=0.057p
+ AD=0.0525p PS=0.68u PD=0.65u rfmode=0
M$2336 RBL[36] RWL[30] \$2570 GND sg13_lv_nmos L=0.13u W=0.3u AS=0.057p
+ AD=0.0525p PS=0.68u PD=0.65u rfmode=0
M$2337 RBL[37] RWL[30] \$2567 GND sg13_lv_nmos L=0.13u W=0.3u AS=0.057p
+ AD=0.0525p PS=0.68u PD=0.65u rfmode=0
M$2338 \$2596 \$2544 GND GND sg13_lv_nmos L=0.13u W=0.3u AS=0.0525p
+ AD=0.331736842105p PS=0.65u PD=2.24315789474u rfmode=0
M$2339 \$2597 \$2545 GND GND sg13_lv_nmos L=0.13u W=0.3u AS=0.0525p
+ AD=0.331736842105p PS=0.65u PD=2.24315789474u rfmode=0
M$2340 \$2599 \$2546 GND GND sg13_lv_nmos L=0.13u W=0.3u AS=0.0525p
+ AD=0.331736842105p PS=0.65u PD=2.24315789474u rfmode=0
M$2341 \$2601 \$2547 GND GND sg13_lv_nmos L=0.13u W=0.3u AS=0.0525p
+ AD=0.331736842105p PS=0.65u PD=2.24315789474u rfmode=0
M$2342 \$2602 \$2548 GND GND sg13_lv_nmos L=0.13u W=0.3u AS=0.0525p
+ AD=0.331736842105p PS=0.65u PD=2.24315789474u rfmode=0
M$2343 \$2600 \$2549 GND GND sg13_lv_nmos L=0.13u W=0.3u AS=0.0525p
+ AD=0.331736842105p PS=0.65u PD=2.24315789474u rfmode=0
M$2344 \$2598 \$2550 GND GND sg13_lv_nmos L=0.13u W=0.3u AS=0.0525p
+ AD=0.331736842105p PS=0.65u PD=2.24315789474u rfmode=0
M$2345 \$2595 \$2551 GND GND sg13_lv_nmos L=0.13u W=0.3u AS=0.0525p
+ AD=0.331736842105p PS=0.65u PD=2.24315789474u rfmode=0
M$2346 \$2594 \$2552 GND GND sg13_lv_nmos L=0.13u W=0.3u AS=0.0525p
+ AD=0.331736842105p PS=0.65u PD=2.24315789474u rfmode=0
M$2347 \$2591 \$2553 GND GND sg13_lv_nmos L=0.13u W=0.3u AS=0.0525p
+ AD=0.331736842105p PS=0.65u PD=2.24315789474u rfmode=0
M$2348 \$2589 \$2554 GND GND sg13_lv_nmos L=0.13u W=0.3u AS=0.0525p
+ AD=0.331736842105p PS=0.65u PD=2.24315789474u rfmode=0
M$2349 \$2586 \$2555 GND GND sg13_lv_nmos L=0.13u W=0.3u AS=0.0525p
+ AD=0.331736842105p PS=0.65u PD=2.24315789474u rfmode=0
M$2350 \$2583 \$2556 GND GND sg13_lv_nmos L=0.13u W=0.3u AS=0.0525p
+ AD=0.331736842105p PS=0.65u PD=2.24315789474u rfmode=0
M$2351 \$2581 \$2557 GND GND sg13_lv_nmos L=0.13u W=0.3u AS=0.0525p
+ AD=0.331736842105p PS=0.65u PD=2.24315789474u rfmode=0
M$2352 \$2578 \$2558 GND GND sg13_lv_nmos L=0.13u W=0.3u AS=0.0525p
+ AD=0.331736842105p PS=0.65u PD=2.24315789474u rfmode=0
M$2353 \$2576 \$2559 GND GND sg13_lv_nmos L=0.13u W=0.3u AS=0.0525p
+ AD=0.331736842105p PS=0.65u PD=2.24315789474u rfmode=0
M$2354 \$2573 \$2560 GND GND sg13_lv_nmos L=0.13u W=0.3u AS=0.0525p
+ AD=0.331736842105p PS=0.65u PD=2.24315789474u rfmode=0
M$2355 \$2570 \$2561 GND GND sg13_lv_nmos L=0.13u W=0.3u AS=0.0525p
+ AD=0.331736842105p PS=0.65u PD=2.24315789474u rfmode=0
M$2356 \$2567 \$2562 GND GND sg13_lv_nmos L=0.13u W=0.3u AS=0.0525p
+ AD=0.331736842105p PS=0.65u PD=2.24315789474u rfmode=0
M$2357 GND \$2603 \$2648 GND sg13_lv_nmos L=0.13u W=0.3u AS=0.331736842105p
+ AD=0.0525p PS=2.24315789474u PD=0.65u rfmode=0
M$2358 GND \$2604 \$2650 GND sg13_lv_nmos L=0.13u W=0.3u AS=0.331736842105p
+ AD=0.0525p PS=2.24315789474u PD=0.65u rfmode=0
M$2359 GND \$2605 \$2651 GND sg13_lv_nmos L=0.13u W=0.3u AS=0.331736842105p
+ AD=0.0525p PS=2.24315789474u PD=0.65u rfmode=0
M$2360 GND \$2606 \$2653 GND sg13_lv_nmos L=0.13u W=0.3u AS=0.331736842105p
+ AD=0.0525p PS=2.24315789474u PD=0.65u rfmode=0
M$2361 GND \$2607 \$2655 GND sg13_lv_nmos L=0.13u W=0.3u AS=0.331736842105p
+ AD=0.0525p PS=2.24315789474u PD=0.65u rfmode=0
M$2362 GND \$2608 \$2657 GND sg13_lv_nmos L=0.13u W=0.3u AS=0.331736842105p
+ AD=0.0525p PS=2.24315789474u PD=0.65u rfmode=0
M$2363 GND \$2609 \$2658 GND sg13_lv_nmos L=0.13u W=0.3u AS=0.331736842105p
+ AD=0.0525p PS=2.24315789474u PD=0.65u rfmode=0
M$2364 GND \$2610 \$2660 GND sg13_lv_nmos L=0.13u W=0.3u AS=0.331736842105p
+ AD=0.0525p PS=2.24315789474u PD=0.65u rfmode=0
M$2365 GND \$2611 \$2661 GND sg13_lv_nmos L=0.13u W=0.3u AS=0.331736842105p
+ AD=0.0525p PS=2.24315789474u PD=0.65u rfmode=0
M$2366 GND \$2612 \$2663 GND sg13_lv_nmos L=0.13u W=0.3u AS=0.331736842105p
+ AD=0.0525p PS=2.24315789474u PD=0.65u rfmode=0
M$2367 GND \$2613 \$2665 GND sg13_lv_nmos L=0.13u W=0.3u AS=0.331736842105p
+ AD=0.0525p PS=2.24315789474u PD=0.65u rfmode=0
M$2368 GND \$2614 \$2666 GND sg13_lv_nmos L=0.13u W=0.3u AS=0.331736842105p
+ AD=0.0525p PS=2.24315789474u PD=0.65u rfmode=0
M$2369 GND \$2615 \$2668 GND sg13_lv_nmos L=0.13u W=0.3u AS=0.331736842105p
+ AD=0.0525p PS=2.24315789474u PD=0.65u rfmode=0
M$2370 GND \$2616 \$2669 GND sg13_lv_nmos L=0.13u W=0.3u AS=0.331736842105p
+ AD=0.0525p PS=2.24315789474u PD=0.65u rfmode=0
M$2371 GND \$2617 \$2671 GND sg13_lv_nmos L=0.13u W=0.3u AS=0.331736842105p
+ AD=0.0525p PS=2.24315789474u PD=0.65u rfmode=0
M$2372 GND \$2618 \$2673 GND sg13_lv_nmos L=0.13u W=0.3u AS=0.331736842105p
+ AD=0.0525p PS=2.24315789474u PD=0.65u rfmode=0
M$2373 GND \$2619 \$2674 GND sg13_lv_nmos L=0.13u W=0.3u AS=0.331736842105p
+ AD=0.0525p PS=2.24315789474u PD=0.65u rfmode=0
M$2374 GND \$2620 \$2676 GND sg13_lv_nmos L=0.13u W=0.3u AS=0.331736842105p
+ AD=0.0525p PS=2.24315789474u PD=0.65u rfmode=0
M$2375 GND \$2621 \$2677 GND sg13_lv_nmos L=0.13u W=0.3u AS=0.331736842105p
+ AD=0.0525p PS=2.24315789474u PD=0.65u rfmode=0
M$2376 \$2648 RWL[31] RBL[0] GND sg13_lv_nmos L=0.13u W=0.3u AS=0.0525p
+ AD=0.102p PS=0.65u PD=1.28u rfmode=0
M$2377 \$2650 RWL[31] RBL[1] GND sg13_lv_nmos L=0.13u W=0.3u AS=0.0525p
+ AD=0.102p PS=0.65u PD=1.28u rfmode=0
M$2378 \$2651 RWL[31] RBL[2] GND sg13_lv_nmos L=0.13u W=0.3u AS=0.0525p
+ AD=0.102p PS=0.65u PD=1.28u rfmode=0
M$2379 \$2653 RWL[31] RBL[3] GND sg13_lv_nmos L=0.13u W=0.3u AS=0.0525p
+ AD=0.102p PS=0.65u PD=1.28u rfmode=0
M$2380 \$2655 RWL[31] RBL[4] GND sg13_lv_nmos L=0.13u W=0.3u AS=0.0525p
+ AD=0.102p PS=0.65u PD=1.28u rfmode=0
M$2381 \$2657 RWL[31] RBL[5] GND sg13_lv_nmos L=0.13u W=0.3u AS=0.0525p
+ AD=0.102p PS=0.65u PD=1.28u rfmode=0
M$2382 \$2658 RWL[31] RBL[6] GND sg13_lv_nmos L=0.13u W=0.3u AS=0.0525p
+ AD=0.102p PS=0.65u PD=1.28u rfmode=0
M$2383 \$2660 RWL[31] RBL[7] GND sg13_lv_nmos L=0.13u W=0.3u AS=0.0525p
+ AD=0.102p PS=0.65u PD=1.28u rfmode=0
M$2384 \$2661 RWL[31] RBL[8] GND sg13_lv_nmos L=0.13u W=0.3u AS=0.0525p
+ AD=0.102p PS=0.65u PD=1.28u rfmode=0
M$2385 \$2663 RWL[31] RBL[9] GND sg13_lv_nmos L=0.13u W=0.3u AS=0.0525p
+ AD=0.102p PS=0.65u PD=1.28u rfmode=0
M$2386 \$2665 RWL[31] RBL[10] GND sg13_lv_nmos L=0.13u W=0.3u AS=0.0525p
+ AD=0.102p PS=0.65u PD=1.28u rfmode=0
M$2387 \$2666 RWL[31] RBL[11] GND sg13_lv_nmos L=0.13u W=0.3u AS=0.0525p
+ AD=0.102p PS=0.65u PD=1.28u rfmode=0
M$2388 \$2668 RWL[31] RBL[12] GND sg13_lv_nmos L=0.13u W=0.3u AS=0.0525p
+ AD=0.102p PS=0.65u PD=1.28u rfmode=0
M$2389 \$2669 RWL[31] RBL[13] GND sg13_lv_nmos L=0.13u W=0.3u AS=0.0525p
+ AD=0.102p PS=0.65u PD=1.28u rfmode=0
M$2390 \$2671 RWL[31] RBL[14] GND sg13_lv_nmos L=0.13u W=0.3u AS=0.0525p
+ AD=0.102p PS=0.65u PD=1.28u rfmode=0
M$2391 \$2673 RWL[31] RBL[15] GND sg13_lv_nmos L=0.13u W=0.3u AS=0.0525p
+ AD=0.102p PS=0.65u PD=1.28u rfmode=0
M$2392 \$2674 RWL[31] RBL[16] GND sg13_lv_nmos L=0.13u W=0.3u AS=0.0525p
+ AD=0.102p PS=0.65u PD=1.28u rfmode=0
M$2393 \$2676 RWL[31] RBL[17] GND sg13_lv_nmos L=0.13u W=0.3u AS=0.0525p
+ AD=0.102p PS=0.65u PD=1.28u rfmode=0
M$2394 \$2677 RWL[31] RBL[18] GND sg13_lv_nmos L=0.13u W=0.3u AS=0.0525p
+ AD=0.102p PS=0.65u PD=1.28u rfmode=0
M$2395 GND \$2622 \$2679 GND sg13_lv_nmos L=0.13u W=0.3u AS=0.331736842105p
+ AD=0.0525p PS=2.24315789474u PD=0.65u rfmode=0
M$2396 GND \$2623 \$2681 GND sg13_lv_nmos L=0.13u W=0.3u AS=0.331736842105p
+ AD=0.0525p PS=2.24315789474u PD=0.65u rfmode=0
M$2397 GND \$2624 \$2683 GND sg13_lv_nmos L=0.13u W=0.3u AS=0.331736842105p
+ AD=0.0525p PS=2.24315789474u PD=0.65u rfmode=0
M$2398 GND \$2625 \$2684 GND sg13_lv_nmos L=0.13u W=0.3u AS=0.331736842105p
+ AD=0.0525p PS=2.24315789474u PD=0.65u rfmode=0
M$2399 GND \$2626 \$2682 GND sg13_lv_nmos L=0.13u W=0.3u AS=0.331736842105p
+ AD=0.0525p PS=2.24315789474u PD=0.65u rfmode=0
M$2400 GND \$2627 \$2680 GND sg13_lv_nmos L=0.13u W=0.3u AS=0.331736842105p
+ AD=0.0525p PS=2.24315789474u PD=0.65u rfmode=0
M$2401 GND \$2628 \$2678 GND sg13_lv_nmos L=0.13u W=0.3u AS=0.331736842105p
+ AD=0.0525p PS=2.24315789474u PD=0.65u rfmode=0
M$2402 GND \$2629 \$2675 GND sg13_lv_nmos L=0.13u W=0.3u AS=0.331736842105p
+ AD=0.0525p PS=2.24315789474u PD=0.65u rfmode=0
M$2403 GND \$2630 \$2672 GND sg13_lv_nmos L=0.13u W=0.3u AS=0.331736842105p
+ AD=0.0525p PS=2.24315789474u PD=0.65u rfmode=0
M$2404 GND \$2631 \$2670 GND sg13_lv_nmos L=0.13u W=0.3u AS=0.331736842105p
+ AD=0.0525p PS=2.24315789474u PD=0.65u rfmode=0
M$2405 GND \$2632 \$2667 GND sg13_lv_nmos L=0.13u W=0.3u AS=0.331736842105p
+ AD=0.0525p PS=2.24315789474u PD=0.65u rfmode=0
M$2406 GND \$2633 \$2664 GND sg13_lv_nmos L=0.13u W=0.3u AS=0.331736842105p
+ AD=0.0525p PS=2.24315789474u PD=0.65u rfmode=0
M$2407 GND \$2634 \$2662 GND sg13_lv_nmos L=0.13u W=0.3u AS=0.331736842105p
+ AD=0.0525p PS=2.24315789474u PD=0.65u rfmode=0
M$2408 GND \$2635 \$2659 GND sg13_lv_nmos L=0.13u W=0.3u AS=0.331736842105p
+ AD=0.0525p PS=2.24315789474u PD=0.65u rfmode=0
M$2409 GND \$2636 \$2656 GND sg13_lv_nmos L=0.13u W=0.3u AS=0.331736842105p
+ AD=0.0525p PS=2.24315789474u PD=0.65u rfmode=0
M$2410 GND \$2637 \$2654 GND sg13_lv_nmos L=0.13u W=0.3u AS=0.331736842105p
+ AD=0.0525p PS=2.24315789474u PD=0.65u rfmode=0
M$2411 GND \$2638 \$2652 GND sg13_lv_nmos L=0.13u W=0.3u AS=0.331736842105p
+ AD=0.0525p PS=2.24315789474u PD=0.65u rfmode=0
M$2412 GND \$2639 \$2649 GND sg13_lv_nmos L=0.13u W=0.3u AS=0.331736842105p
+ AD=0.0525p PS=2.24315789474u PD=0.65u rfmode=0
M$2413 GND \$2640 \$2647 GND sg13_lv_nmos L=0.13u W=0.3u AS=0.331736842105p
+ AD=0.0525p PS=2.24315789474u PD=0.65u rfmode=0
M$2414 \$2679 RWL[31] RBL[19] GND sg13_lv_nmos L=0.13u W=0.3u AS=0.0525p
+ AD=0.102p PS=0.65u PD=1.28u rfmode=0
M$2415 \$2681 RWL[31] RBL[20] GND sg13_lv_nmos L=0.13u W=0.3u AS=0.0525p
+ AD=0.102p PS=0.65u PD=1.28u rfmode=0
M$2416 \$2683 RWL[31] RBL[21] GND sg13_lv_nmos L=0.13u W=0.3u AS=0.0525p
+ AD=0.102p PS=0.65u PD=1.28u rfmode=0
M$2417 \$2684 RWL[31] RBL[22] GND sg13_lv_nmos L=0.13u W=0.3u AS=0.0525p
+ AD=0.102p PS=0.65u PD=1.28u rfmode=0
M$2418 \$2682 RWL[31] RBL[23] GND sg13_lv_nmos L=0.13u W=0.3u AS=0.0525p
+ AD=0.102p PS=0.65u PD=1.28u rfmode=0
M$2419 \$2680 RWL[31] RBL[24] GND sg13_lv_nmos L=0.13u W=0.3u AS=0.0525p
+ AD=0.102p PS=0.65u PD=1.28u rfmode=0
M$2420 \$2678 RWL[31] RBL[25] GND sg13_lv_nmos L=0.13u W=0.3u AS=0.0525p
+ AD=0.102p PS=0.65u PD=1.28u rfmode=0
M$2421 \$2675 RWL[31] RBL[26] GND sg13_lv_nmos L=0.13u W=0.3u AS=0.0525p
+ AD=0.102p PS=0.65u PD=1.28u rfmode=0
M$2422 \$2672 RWL[31] RBL[27] GND sg13_lv_nmos L=0.13u W=0.3u AS=0.0525p
+ AD=0.102p PS=0.65u PD=1.28u rfmode=0
M$2423 \$2670 RWL[31] RBL[28] GND sg13_lv_nmos L=0.13u W=0.3u AS=0.0525p
+ AD=0.102p PS=0.65u PD=1.28u rfmode=0
M$2424 \$2667 RWL[31] RBL[29] GND sg13_lv_nmos L=0.13u W=0.3u AS=0.0525p
+ AD=0.102p PS=0.65u PD=1.28u rfmode=0
M$2425 \$2664 RWL[31] RBL[30] GND sg13_lv_nmos L=0.13u W=0.3u AS=0.0525p
+ AD=0.102p PS=0.65u PD=1.28u rfmode=0
M$2426 \$2662 RWL[31] RBL[31] GND sg13_lv_nmos L=0.13u W=0.3u AS=0.0525p
+ AD=0.102p PS=0.65u PD=1.28u rfmode=0
M$2427 \$2659 RWL[31] RBL[32] GND sg13_lv_nmos L=0.13u W=0.3u AS=0.0525p
+ AD=0.102p PS=0.65u PD=1.28u rfmode=0
M$2428 \$2656 RWL[31] RBL[33] GND sg13_lv_nmos L=0.13u W=0.3u AS=0.0525p
+ AD=0.102p PS=0.65u PD=1.28u rfmode=0
M$2429 \$2654 RWL[31] RBL[34] GND sg13_lv_nmos L=0.13u W=0.3u AS=0.0525p
+ AD=0.102p PS=0.65u PD=1.28u rfmode=0
M$2430 \$2652 RWL[31] RBL[35] GND sg13_lv_nmos L=0.13u W=0.3u AS=0.0525p
+ AD=0.102p PS=0.65u PD=1.28u rfmode=0
M$2431 \$2649 RWL[31] RBL[36] GND sg13_lv_nmos L=0.13u W=0.3u AS=0.0525p
+ AD=0.102p PS=0.65u PD=1.28u rfmode=0
M$2432 \$2647 RWL[31] RBL[37] GND sg13_lv_nmos L=0.13u W=0.3u AS=0.0525p
+ AD=0.102p PS=0.65u PD=1.28u rfmode=0
M$2433 \$41 WWL[0] WBL[0] GND sg13_hv_nmos L=0.45u W=0.15u AS=0.1005p
+ AD=0.0555p PS=1.34u PD=0.74u rfmode=0
M$2434 WBL[0] WWL[1] \$121 GND sg13_hv_nmos L=0.45u W=0.15u AS=0.0555p
+ AD=0.1005p PS=0.74u PD=1.34u rfmode=0
M$2435 \$42 WWL[0] WBL[1] GND sg13_hv_nmos L=0.45u W=0.15u AS=0.1005p
+ AD=0.0555p PS=1.34u PD=0.74u rfmode=0
M$2436 WBL[1] WWL[1] \$123 GND sg13_hv_nmos L=0.45u W=0.15u AS=0.0555p
+ AD=0.1005p PS=0.74u PD=1.34u rfmode=0
M$2437 \$43 WWL[0] WBL[2] GND sg13_hv_nmos L=0.45u W=0.15u AS=0.1005p
+ AD=0.0555p PS=1.34u PD=0.74u rfmode=0
M$2438 WBL[2] WWL[1] \$124 GND sg13_hv_nmos L=0.45u W=0.15u AS=0.0555p
+ AD=0.1005p PS=0.74u PD=1.34u rfmode=0
M$2439 \$44 WWL[0] WBL[3] GND sg13_hv_nmos L=0.45u W=0.15u AS=0.1005p
+ AD=0.0555p PS=1.34u PD=0.74u rfmode=0
M$2440 WBL[3] WWL[1] \$127 GND sg13_hv_nmos L=0.45u W=0.15u AS=0.0555p
+ AD=0.1005p PS=0.74u PD=1.34u rfmode=0
M$2441 \$45 WWL[0] WBL[4] GND sg13_hv_nmos L=0.45u W=0.15u AS=0.1005p
+ AD=0.0555p PS=1.34u PD=0.74u rfmode=0
M$2442 WBL[4] WWL[1] \$129 GND sg13_hv_nmos L=0.45u W=0.15u AS=0.0555p
+ AD=0.1005p PS=0.74u PD=1.34u rfmode=0
M$2443 \$46 WWL[0] WBL[5] GND sg13_hv_nmos L=0.45u W=0.15u AS=0.1005p
+ AD=0.0555p PS=1.34u PD=0.74u rfmode=0
M$2444 WBL[5] WWL[1] \$131 GND sg13_hv_nmos L=0.45u W=0.15u AS=0.0555p
+ AD=0.1005p PS=0.74u PD=1.34u rfmode=0
M$2445 \$47 WWL[0] WBL[6] GND sg13_hv_nmos L=0.45u W=0.15u AS=0.1005p
+ AD=0.0555p PS=1.34u PD=0.74u rfmode=0
M$2446 WBL[6] WWL[1] \$132 GND sg13_hv_nmos L=0.45u W=0.15u AS=0.0555p
+ AD=0.1005p PS=0.74u PD=1.34u rfmode=0
M$2447 \$48 WWL[0] WBL[7] GND sg13_hv_nmos L=0.45u W=0.15u AS=0.1005p
+ AD=0.0555p PS=1.34u PD=0.74u rfmode=0
M$2448 WBL[7] WWL[1] \$134 GND sg13_hv_nmos L=0.45u W=0.15u AS=0.0555p
+ AD=0.1005p PS=0.74u PD=1.34u rfmode=0
M$2449 \$49 WWL[0] WBL[8] GND sg13_hv_nmos L=0.45u W=0.15u AS=0.1005p
+ AD=0.0555p PS=1.34u PD=0.74u rfmode=0
M$2450 WBL[8] WWL[1] \$137 GND sg13_hv_nmos L=0.45u W=0.15u AS=0.0555p
+ AD=0.1005p PS=0.74u PD=1.34u rfmode=0
M$2451 \$50 WWL[0] WBL[9] GND sg13_hv_nmos L=0.45u W=0.15u AS=0.1005p
+ AD=0.0555p PS=1.34u PD=0.74u rfmode=0
M$2452 WBL[9] WWL[1] \$138 GND sg13_hv_nmos L=0.45u W=0.15u AS=0.0555p
+ AD=0.1005p PS=0.74u PD=1.34u rfmode=0
M$2453 \$51 WWL[0] WBL[10] GND sg13_hv_nmos L=0.45u W=0.15u AS=0.1005p
+ AD=0.0555p PS=1.34u PD=0.74u rfmode=0
M$2454 WBL[10] WWL[1] \$140 GND sg13_hv_nmos L=0.45u W=0.15u AS=0.0555p
+ AD=0.1005p PS=0.74u PD=1.34u rfmode=0
M$2455 \$52 WWL[0] WBL[11] GND sg13_hv_nmos L=0.45u W=0.15u AS=0.1005p
+ AD=0.0555p PS=1.34u PD=0.74u rfmode=0
M$2456 WBL[11] WWL[1] \$143 GND sg13_hv_nmos L=0.45u W=0.15u AS=0.0555p
+ AD=0.1005p PS=0.74u PD=1.34u rfmode=0
M$2457 \$53 WWL[0] WBL[12] GND sg13_hv_nmos L=0.45u W=0.15u AS=0.1005p
+ AD=0.0555p PS=1.34u PD=0.74u rfmode=0
M$2458 WBL[12] WWL[1] \$145 GND sg13_hv_nmos L=0.45u W=0.15u AS=0.0555p
+ AD=0.1005p PS=0.74u PD=1.34u rfmode=0
M$2459 \$54 WWL[0] WBL[13] GND sg13_hv_nmos L=0.45u W=0.15u AS=0.1005p
+ AD=0.0555p PS=1.34u PD=0.74u rfmode=0
M$2460 WBL[13] WWL[1] \$146 GND sg13_hv_nmos L=0.45u W=0.15u AS=0.0555p
+ AD=0.1005p PS=0.74u PD=1.34u rfmode=0
M$2461 \$55 WWL[0] WBL[14] GND sg13_hv_nmos L=0.45u W=0.15u AS=0.1005p
+ AD=0.0555p PS=1.34u PD=0.74u rfmode=0
M$2462 WBL[14] WWL[1] \$148 GND sg13_hv_nmos L=0.45u W=0.15u AS=0.0555p
+ AD=0.1005p PS=0.74u PD=1.34u rfmode=0
M$2463 \$56 WWL[0] WBL[15] GND sg13_hv_nmos L=0.45u W=0.15u AS=0.1005p
+ AD=0.0555p PS=1.34u PD=0.74u rfmode=0
M$2464 WBL[15] WWL[1] \$150 GND sg13_hv_nmos L=0.45u W=0.15u AS=0.0555p
+ AD=0.1005p PS=0.74u PD=1.34u rfmode=0
M$2465 \$57 WWL[0] WBL[16] GND sg13_hv_nmos L=0.45u W=0.15u AS=0.1005p
+ AD=0.0555p PS=1.34u PD=0.74u rfmode=0
M$2466 WBL[16] WWL[1] \$152 GND sg13_hv_nmos L=0.45u W=0.15u AS=0.0555p
+ AD=0.1005p PS=0.74u PD=1.34u rfmode=0
M$2467 \$58 WWL[0] WBL[17] GND sg13_hv_nmos L=0.45u W=0.15u AS=0.1005p
+ AD=0.0555p PS=1.34u PD=0.74u rfmode=0
M$2468 WBL[17] WWL[1] \$154 GND sg13_hv_nmos L=0.45u W=0.15u AS=0.0555p
+ AD=0.1005p PS=0.74u PD=1.34u rfmode=0
M$2469 \$59 WWL[0] WBL[18] GND sg13_hv_nmos L=0.45u W=0.15u AS=0.1005p
+ AD=0.0555p PS=1.34u PD=0.74u rfmode=0
M$2470 WBL[18] WWL[1] \$157 GND sg13_hv_nmos L=0.45u W=0.15u AS=0.0555p
+ AD=0.1005p PS=0.74u PD=1.34u rfmode=0
M$2471 \$60 WWL[0] WBL[19] GND sg13_hv_nmos L=0.45u W=0.15u AS=0.1005p
+ AD=0.0555p PS=1.34u PD=0.74u rfmode=0
M$2472 WBL[19] WWL[1] \$158 GND sg13_hv_nmos L=0.45u W=0.15u AS=0.0555p
+ AD=0.1005p PS=0.74u PD=1.34u rfmode=0
M$2473 \$61 WWL[0] WBL[20] GND sg13_hv_nmos L=0.45u W=0.15u AS=0.1005p
+ AD=0.0555p PS=1.34u PD=0.74u rfmode=0
M$2474 WBL[20] WWL[1] \$160 GND sg13_hv_nmos L=0.45u W=0.15u AS=0.0555p
+ AD=0.1005p PS=0.74u PD=1.34u rfmode=0
M$2475 \$62 WWL[0] WBL[21] GND sg13_hv_nmos L=0.45u W=0.15u AS=0.1005p
+ AD=0.0555p PS=1.34u PD=0.74u rfmode=0
M$2476 WBL[21] WWL[1] \$162 GND sg13_hv_nmos L=0.45u W=0.15u AS=0.0555p
+ AD=0.1005p PS=0.74u PD=1.34u rfmode=0
M$2477 \$63 WWL[0] WBL[22] GND sg13_hv_nmos L=0.45u W=0.15u AS=0.1005p
+ AD=0.0555p PS=1.34u PD=0.74u rfmode=0
M$2478 WBL[22] WWL[1] \$165 GND sg13_hv_nmos L=0.45u W=0.15u AS=0.0555p
+ AD=0.1005p PS=0.74u PD=1.34u rfmode=0
M$2479 \$64 WWL[0] WBL[23] GND sg13_hv_nmos L=0.45u W=0.15u AS=0.1005p
+ AD=0.0555p PS=1.34u PD=0.74u rfmode=0
M$2480 WBL[23] WWL[1] \$167 GND sg13_hv_nmos L=0.45u W=0.15u AS=0.0555p
+ AD=0.1005p PS=0.74u PD=1.34u rfmode=0
M$2481 \$65 WWL[0] WBL[24] GND sg13_hv_nmos L=0.45u W=0.15u AS=0.1005p
+ AD=0.0555p PS=1.34u PD=0.74u rfmode=0
M$2482 WBL[24] WWL[1] \$169 GND sg13_hv_nmos L=0.45u W=0.15u AS=0.0555p
+ AD=0.1005p PS=0.74u PD=1.34u rfmode=0
M$2483 \$66 WWL[0] WBL[25] GND sg13_hv_nmos L=0.45u W=0.15u AS=0.1005p
+ AD=0.0555p PS=1.34u PD=0.74u rfmode=0
M$2484 WBL[25] WWL[1] \$170 GND sg13_hv_nmos L=0.45u W=0.15u AS=0.0555p
+ AD=0.1005p PS=0.74u PD=1.34u rfmode=0
M$2485 \$67 WWL[0] WBL[26] GND sg13_hv_nmos L=0.45u W=0.15u AS=0.1005p
+ AD=0.0555p PS=1.34u PD=0.74u rfmode=0
M$2486 WBL[26] WWL[1] \$173 GND sg13_hv_nmos L=0.45u W=0.15u AS=0.0555p
+ AD=0.1005p PS=0.74u PD=1.34u rfmode=0
M$2487 \$68 WWL[0] WBL[27] GND sg13_hv_nmos L=0.45u W=0.15u AS=0.1005p
+ AD=0.0555p PS=1.34u PD=0.74u rfmode=0
M$2488 WBL[27] WWL[1] \$174 GND sg13_hv_nmos L=0.45u W=0.15u AS=0.0555p
+ AD=0.1005p PS=0.74u PD=1.34u rfmode=0
M$2489 \$69 WWL[0] WBL[28] GND sg13_hv_nmos L=0.45u W=0.15u AS=0.1005p
+ AD=0.0555p PS=1.34u PD=0.74u rfmode=0
M$2490 WBL[28] WWL[1] \$176 GND sg13_hv_nmos L=0.45u W=0.15u AS=0.0555p
+ AD=0.1005p PS=0.74u PD=1.34u rfmode=0
M$2491 \$70 WWL[0] WBL[29] GND sg13_hv_nmos L=0.45u W=0.15u AS=0.1005p
+ AD=0.0555p PS=1.34u PD=0.74u rfmode=0
M$2492 WBL[29] WWL[1] \$179 GND sg13_hv_nmos L=0.45u W=0.15u AS=0.0555p
+ AD=0.1005p PS=0.74u PD=1.34u rfmode=0
M$2493 \$71 WWL[0] WBL[30] GND sg13_hv_nmos L=0.45u W=0.15u AS=0.1005p
+ AD=0.0555p PS=1.34u PD=0.74u rfmode=0
M$2494 WBL[30] WWL[1] \$180 GND sg13_hv_nmos L=0.45u W=0.15u AS=0.0555p
+ AD=0.1005p PS=0.74u PD=1.34u rfmode=0
M$2495 \$72 WWL[0] WBL[31] GND sg13_hv_nmos L=0.45u W=0.15u AS=0.1005p
+ AD=0.0555p PS=1.34u PD=0.74u rfmode=0
M$2496 WBL[31] WWL[1] \$183 GND sg13_hv_nmos L=0.45u W=0.15u AS=0.0555p
+ AD=0.1005p PS=0.74u PD=1.34u rfmode=0
M$2497 \$73 WWL[0] WBL[32] GND sg13_hv_nmos L=0.45u W=0.15u AS=0.1005p
+ AD=0.0555p PS=1.34u PD=0.74u rfmode=0
M$2498 WBL[32] WWL[1] \$185 GND sg13_hv_nmos L=0.45u W=0.15u AS=0.0555p
+ AD=0.1005p PS=0.74u PD=1.34u rfmode=0
M$2499 \$74 WWL[0] WBL[33] GND sg13_hv_nmos L=0.45u W=0.15u AS=0.1005p
+ AD=0.0555p PS=1.34u PD=0.74u rfmode=0
M$2500 WBL[33] WWL[1] \$186 GND sg13_hv_nmos L=0.45u W=0.15u AS=0.0555p
+ AD=0.1005p PS=0.74u PD=1.34u rfmode=0
M$2501 \$75 WWL[0] WBL[34] GND sg13_hv_nmos L=0.45u W=0.15u AS=0.1005p
+ AD=0.0555p PS=1.34u PD=0.74u rfmode=0
M$2502 WBL[34] WWL[1] \$189 GND sg13_hv_nmos L=0.45u W=0.15u AS=0.0555p
+ AD=0.1005p PS=0.74u PD=1.34u rfmode=0
M$2503 \$76 WWL[0] WBL[35] GND sg13_hv_nmos L=0.45u W=0.15u AS=0.1005p
+ AD=0.0555p PS=1.34u PD=0.74u rfmode=0
M$2504 WBL[35] WWL[1] \$190 GND sg13_hv_nmos L=0.45u W=0.15u AS=0.0555p
+ AD=0.1005p PS=0.74u PD=1.34u rfmode=0
M$2505 \$77 WWL[0] WBL[36] GND sg13_hv_nmos L=0.45u W=0.15u AS=0.1005p
+ AD=0.0555p PS=1.34u PD=0.74u rfmode=0
M$2506 WBL[36] WWL[1] \$192 GND sg13_hv_nmos L=0.45u W=0.15u AS=0.0555p
+ AD=0.1005p PS=0.74u PD=1.34u rfmode=0
M$2507 \$78 WWL[0] WBL[37] GND sg13_hv_nmos L=0.45u W=0.15u AS=0.1005p
+ AD=0.0555p PS=1.34u PD=0.74u rfmode=0
M$2508 WBL[37] WWL[1] \$195 GND sg13_hv_nmos L=0.45u W=0.15u AS=0.0555p
+ AD=0.1005p PS=0.74u PD=1.34u rfmode=0
M$2509 \$243 WWL[2] WBL[0] GND sg13_hv_nmos L=0.45u W=0.15u AS=0.1005p
+ AD=0.0555p PS=1.34u PD=0.74u rfmode=0
M$2510 WBL[0] WWL[3] \$321 GND sg13_hv_nmos L=0.45u W=0.15u AS=0.0555p
+ AD=0.1005p PS=0.74u PD=1.34u rfmode=0
M$2511 \$244 WWL[2] WBL[1] GND sg13_hv_nmos L=0.45u W=0.15u AS=0.1005p
+ AD=0.0555p PS=1.34u PD=0.74u rfmode=0
M$2512 WBL[1] WWL[3] \$322 GND sg13_hv_nmos L=0.45u W=0.15u AS=0.0555p
+ AD=0.1005p PS=0.74u PD=1.34u rfmode=0
M$2513 \$245 WWL[2] WBL[2] GND sg13_hv_nmos L=0.45u W=0.15u AS=0.1005p
+ AD=0.0555p PS=1.34u PD=0.74u rfmode=0
M$2514 WBL[2] WWL[3] \$323 GND sg13_hv_nmos L=0.45u W=0.15u AS=0.0555p
+ AD=0.1005p PS=0.74u PD=1.34u rfmode=0
M$2515 \$246 WWL[2] WBL[3] GND sg13_hv_nmos L=0.45u W=0.15u AS=0.1005p
+ AD=0.0555p PS=1.34u PD=0.74u rfmode=0
M$2516 WBL[3] WWL[3] \$324 GND sg13_hv_nmos L=0.45u W=0.15u AS=0.0555p
+ AD=0.1005p PS=0.74u PD=1.34u rfmode=0
M$2517 \$247 WWL[2] WBL[4] GND sg13_hv_nmos L=0.45u W=0.15u AS=0.1005p
+ AD=0.0555p PS=1.34u PD=0.74u rfmode=0
M$2518 WBL[4] WWL[3] \$325 GND sg13_hv_nmos L=0.45u W=0.15u AS=0.0555p
+ AD=0.1005p PS=0.74u PD=1.34u rfmode=0
M$2519 \$248 WWL[2] WBL[5] GND sg13_hv_nmos L=0.45u W=0.15u AS=0.1005p
+ AD=0.0555p PS=1.34u PD=0.74u rfmode=0
M$2520 WBL[5] WWL[3] \$326 GND sg13_hv_nmos L=0.45u W=0.15u AS=0.0555p
+ AD=0.1005p PS=0.74u PD=1.34u rfmode=0
M$2521 \$249 WWL[2] WBL[6] GND sg13_hv_nmos L=0.45u W=0.15u AS=0.1005p
+ AD=0.0555p PS=1.34u PD=0.74u rfmode=0
M$2522 WBL[6] WWL[3] \$327 GND sg13_hv_nmos L=0.45u W=0.15u AS=0.0555p
+ AD=0.1005p PS=0.74u PD=1.34u rfmode=0
M$2523 \$250 WWL[2] WBL[7] GND sg13_hv_nmos L=0.45u W=0.15u AS=0.1005p
+ AD=0.0555p PS=1.34u PD=0.74u rfmode=0
M$2524 WBL[7] WWL[3] \$328 GND sg13_hv_nmos L=0.45u W=0.15u AS=0.0555p
+ AD=0.1005p PS=0.74u PD=1.34u rfmode=0
M$2525 \$251 WWL[2] WBL[8] GND sg13_hv_nmos L=0.45u W=0.15u AS=0.1005p
+ AD=0.0555p PS=1.34u PD=0.74u rfmode=0
M$2526 WBL[8] WWL[3] \$329 GND sg13_hv_nmos L=0.45u W=0.15u AS=0.0555p
+ AD=0.1005p PS=0.74u PD=1.34u rfmode=0
M$2527 \$252 WWL[2] WBL[9] GND sg13_hv_nmos L=0.45u W=0.15u AS=0.1005p
+ AD=0.0555p PS=1.34u PD=0.74u rfmode=0
M$2528 WBL[9] WWL[3] \$330 GND sg13_hv_nmos L=0.45u W=0.15u AS=0.0555p
+ AD=0.1005p PS=0.74u PD=1.34u rfmode=0
M$2529 \$253 WWL[2] WBL[10] GND sg13_hv_nmos L=0.45u W=0.15u AS=0.1005p
+ AD=0.0555p PS=1.34u PD=0.74u rfmode=0
M$2530 WBL[10] WWL[3] \$331 GND sg13_hv_nmos L=0.45u W=0.15u AS=0.0555p
+ AD=0.1005p PS=0.74u PD=1.34u rfmode=0
M$2531 \$254 WWL[2] WBL[11] GND sg13_hv_nmos L=0.45u W=0.15u AS=0.1005p
+ AD=0.0555p PS=1.34u PD=0.74u rfmode=0
M$2532 WBL[11] WWL[3] \$332 GND sg13_hv_nmos L=0.45u W=0.15u AS=0.0555p
+ AD=0.1005p PS=0.74u PD=1.34u rfmode=0
M$2533 \$255 WWL[2] WBL[12] GND sg13_hv_nmos L=0.45u W=0.15u AS=0.1005p
+ AD=0.0555p PS=1.34u PD=0.74u rfmode=0
M$2534 WBL[12] WWL[3] \$333 GND sg13_hv_nmos L=0.45u W=0.15u AS=0.0555p
+ AD=0.1005p PS=0.74u PD=1.34u rfmode=0
M$2535 \$256 WWL[2] WBL[13] GND sg13_hv_nmos L=0.45u W=0.15u AS=0.1005p
+ AD=0.0555p PS=1.34u PD=0.74u rfmode=0
M$2536 WBL[13] WWL[3] \$334 GND sg13_hv_nmos L=0.45u W=0.15u AS=0.0555p
+ AD=0.1005p PS=0.74u PD=1.34u rfmode=0
M$2537 \$257 WWL[2] WBL[14] GND sg13_hv_nmos L=0.45u W=0.15u AS=0.1005p
+ AD=0.0555p PS=1.34u PD=0.74u rfmode=0
M$2538 WBL[14] WWL[3] \$335 GND sg13_hv_nmos L=0.45u W=0.15u AS=0.0555p
+ AD=0.1005p PS=0.74u PD=1.34u rfmode=0
M$2539 \$258 WWL[2] WBL[15] GND sg13_hv_nmos L=0.45u W=0.15u AS=0.1005p
+ AD=0.0555p PS=1.34u PD=0.74u rfmode=0
M$2540 WBL[15] WWL[3] \$336 GND sg13_hv_nmos L=0.45u W=0.15u AS=0.0555p
+ AD=0.1005p PS=0.74u PD=1.34u rfmode=0
M$2541 \$259 WWL[2] WBL[16] GND sg13_hv_nmos L=0.45u W=0.15u AS=0.1005p
+ AD=0.0555p PS=1.34u PD=0.74u rfmode=0
M$2542 WBL[16] WWL[3] \$337 GND sg13_hv_nmos L=0.45u W=0.15u AS=0.0555p
+ AD=0.1005p PS=0.74u PD=1.34u rfmode=0
M$2543 \$260 WWL[2] WBL[17] GND sg13_hv_nmos L=0.45u W=0.15u AS=0.1005p
+ AD=0.0555p PS=1.34u PD=0.74u rfmode=0
M$2544 WBL[17] WWL[3] \$338 GND sg13_hv_nmos L=0.45u W=0.15u AS=0.0555p
+ AD=0.1005p PS=0.74u PD=1.34u rfmode=0
M$2545 \$261 WWL[2] WBL[18] GND sg13_hv_nmos L=0.45u W=0.15u AS=0.1005p
+ AD=0.0555p PS=1.34u PD=0.74u rfmode=0
M$2546 WBL[18] WWL[3] \$339 GND sg13_hv_nmos L=0.45u W=0.15u AS=0.0555p
+ AD=0.1005p PS=0.74u PD=1.34u rfmode=0
M$2547 \$262 WWL[2] WBL[19] GND sg13_hv_nmos L=0.45u W=0.15u AS=0.1005p
+ AD=0.0555p PS=1.34u PD=0.74u rfmode=0
M$2548 WBL[19] WWL[3] \$340 GND sg13_hv_nmos L=0.45u W=0.15u AS=0.0555p
+ AD=0.1005p PS=0.74u PD=1.34u rfmode=0
M$2549 \$263 WWL[2] WBL[20] GND sg13_hv_nmos L=0.45u W=0.15u AS=0.1005p
+ AD=0.0555p PS=1.34u PD=0.74u rfmode=0
M$2550 WBL[20] WWL[3] \$341 GND sg13_hv_nmos L=0.45u W=0.15u AS=0.0555p
+ AD=0.1005p PS=0.74u PD=1.34u rfmode=0
M$2551 \$264 WWL[2] WBL[21] GND sg13_hv_nmos L=0.45u W=0.15u AS=0.1005p
+ AD=0.0555p PS=1.34u PD=0.74u rfmode=0
M$2552 WBL[21] WWL[3] \$342 GND sg13_hv_nmos L=0.45u W=0.15u AS=0.0555p
+ AD=0.1005p PS=0.74u PD=1.34u rfmode=0
M$2553 \$265 WWL[2] WBL[22] GND sg13_hv_nmos L=0.45u W=0.15u AS=0.1005p
+ AD=0.0555p PS=1.34u PD=0.74u rfmode=0
M$2554 WBL[22] WWL[3] \$343 GND sg13_hv_nmos L=0.45u W=0.15u AS=0.0555p
+ AD=0.1005p PS=0.74u PD=1.34u rfmode=0
M$2555 \$266 WWL[2] WBL[23] GND sg13_hv_nmos L=0.45u W=0.15u AS=0.1005p
+ AD=0.0555p PS=1.34u PD=0.74u rfmode=0
M$2556 WBL[23] WWL[3] \$344 GND sg13_hv_nmos L=0.45u W=0.15u AS=0.0555p
+ AD=0.1005p PS=0.74u PD=1.34u rfmode=0
M$2557 \$267 WWL[2] WBL[24] GND sg13_hv_nmos L=0.45u W=0.15u AS=0.1005p
+ AD=0.0555p PS=1.34u PD=0.74u rfmode=0
M$2558 WBL[24] WWL[3] \$345 GND sg13_hv_nmos L=0.45u W=0.15u AS=0.0555p
+ AD=0.1005p PS=0.74u PD=1.34u rfmode=0
M$2559 \$268 WWL[2] WBL[25] GND sg13_hv_nmos L=0.45u W=0.15u AS=0.1005p
+ AD=0.0555p PS=1.34u PD=0.74u rfmode=0
M$2560 WBL[25] WWL[3] \$346 GND sg13_hv_nmos L=0.45u W=0.15u AS=0.0555p
+ AD=0.1005p PS=0.74u PD=1.34u rfmode=0
M$2561 \$269 WWL[2] WBL[26] GND sg13_hv_nmos L=0.45u W=0.15u AS=0.1005p
+ AD=0.0555p PS=1.34u PD=0.74u rfmode=0
M$2562 WBL[26] WWL[3] \$347 GND sg13_hv_nmos L=0.45u W=0.15u AS=0.0555p
+ AD=0.1005p PS=0.74u PD=1.34u rfmode=0
M$2563 \$270 WWL[2] WBL[27] GND sg13_hv_nmos L=0.45u W=0.15u AS=0.1005p
+ AD=0.0555p PS=1.34u PD=0.74u rfmode=0
M$2564 WBL[27] WWL[3] \$348 GND sg13_hv_nmos L=0.45u W=0.15u AS=0.0555p
+ AD=0.1005p PS=0.74u PD=1.34u rfmode=0
M$2565 \$271 WWL[2] WBL[28] GND sg13_hv_nmos L=0.45u W=0.15u AS=0.1005p
+ AD=0.0555p PS=1.34u PD=0.74u rfmode=0
M$2566 WBL[28] WWL[3] \$349 GND sg13_hv_nmos L=0.45u W=0.15u AS=0.0555p
+ AD=0.1005p PS=0.74u PD=1.34u rfmode=0
M$2567 \$272 WWL[2] WBL[29] GND sg13_hv_nmos L=0.45u W=0.15u AS=0.1005p
+ AD=0.0555p PS=1.34u PD=0.74u rfmode=0
M$2568 WBL[29] WWL[3] \$350 GND sg13_hv_nmos L=0.45u W=0.15u AS=0.0555p
+ AD=0.1005p PS=0.74u PD=1.34u rfmode=0
M$2569 \$273 WWL[2] WBL[30] GND sg13_hv_nmos L=0.45u W=0.15u AS=0.1005p
+ AD=0.0555p PS=1.34u PD=0.74u rfmode=0
M$2570 WBL[30] WWL[3] \$351 GND sg13_hv_nmos L=0.45u W=0.15u AS=0.0555p
+ AD=0.1005p PS=0.74u PD=1.34u rfmode=0
M$2571 \$274 WWL[2] WBL[31] GND sg13_hv_nmos L=0.45u W=0.15u AS=0.1005p
+ AD=0.0555p PS=1.34u PD=0.74u rfmode=0
M$2572 WBL[31] WWL[3] \$352 GND sg13_hv_nmos L=0.45u W=0.15u AS=0.0555p
+ AD=0.1005p PS=0.74u PD=1.34u rfmode=0
M$2573 \$275 WWL[2] WBL[32] GND sg13_hv_nmos L=0.45u W=0.15u AS=0.1005p
+ AD=0.0555p PS=1.34u PD=0.74u rfmode=0
M$2574 WBL[32] WWL[3] \$353 GND sg13_hv_nmos L=0.45u W=0.15u AS=0.0555p
+ AD=0.1005p PS=0.74u PD=1.34u rfmode=0
M$2575 \$276 WWL[2] WBL[33] GND sg13_hv_nmos L=0.45u W=0.15u AS=0.1005p
+ AD=0.0555p PS=1.34u PD=0.74u rfmode=0
M$2576 WBL[33] WWL[3] \$354 GND sg13_hv_nmos L=0.45u W=0.15u AS=0.0555p
+ AD=0.1005p PS=0.74u PD=1.34u rfmode=0
M$2577 \$277 WWL[2] WBL[34] GND sg13_hv_nmos L=0.45u W=0.15u AS=0.1005p
+ AD=0.0555p PS=1.34u PD=0.74u rfmode=0
M$2578 WBL[34] WWL[3] \$355 GND sg13_hv_nmos L=0.45u W=0.15u AS=0.0555p
+ AD=0.1005p PS=0.74u PD=1.34u rfmode=0
M$2579 \$278 WWL[2] WBL[35] GND sg13_hv_nmos L=0.45u W=0.15u AS=0.1005p
+ AD=0.0555p PS=1.34u PD=0.74u rfmode=0
M$2580 WBL[35] WWL[3] \$356 GND sg13_hv_nmos L=0.45u W=0.15u AS=0.0555p
+ AD=0.1005p PS=0.74u PD=1.34u rfmode=0
M$2581 \$279 WWL[2] WBL[36] GND sg13_hv_nmos L=0.45u W=0.15u AS=0.1005p
+ AD=0.0555p PS=1.34u PD=0.74u rfmode=0
M$2582 WBL[36] WWL[3] \$357 GND sg13_hv_nmos L=0.45u W=0.15u AS=0.0555p
+ AD=0.1005p PS=0.74u PD=1.34u rfmode=0
M$2583 \$280 WWL[2] WBL[37] GND sg13_hv_nmos L=0.45u W=0.15u AS=0.1005p
+ AD=0.0555p PS=1.34u PD=0.74u rfmode=0
M$2584 WBL[37] WWL[3] \$358 GND sg13_hv_nmos L=0.45u W=0.15u AS=0.0555p
+ AD=0.1005p PS=0.74u PD=1.34u rfmode=0
M$2585 \$406 WWL[4] WBL[0] GND sg13_hv_nmos L=0.45u W=0.15u AS=0.1005p
+ AD=0.0555p PS=1.34u PD=0.74u rfmode=0
M$2586 WBL[0] WWL[5] \$484 GND sg13_hv_nmos L=0.45u W=0.15u AS=0.0555p
+ AD=0.1005p PS=0.74u PD=1.34u rfmode=0
M$2587 \$407 WWL[4] WBL[1] GND sg13_hv_nmos L=0.45u W=0.15u AS=0.1005p
+ AD=0.0555p PS=1.34u PD=0.74u rfmode=0
M$2588 WBL[1] WWL[5] \$485 GND sg13_hv_nmos L=0.45u W=0.15u AS=0.0555p
+ AD=0.1005p PS=0.74u PD=1.34u rfmode=0
M$2589 \$408 WWL[4] WBL[2] GND sg13_hv_nmos L=0.45u W=0.15u AS=0.1005p
+ AD=0.0555p PS=1.34u PD=0.74u rfmode=0
M$2590 WBL[2] WWL[5] \$486 GND sg13_hv_nmos L=0.45u W=0.15u AS=0.0555p
+ AD=0.1005p PS=0.74u PD=1.34u rfmode=0
M$2591 \$409 WWL[4] WBL[3] GND sg13_hv_nmos L=0.45u W=0.15u AS=0.1005p
+ AD=0.0555p PS=1.34u PD=0.74u rfmode=0
M$2592 WBL[3] WWL[5] \$487 GND sg13_hv_nmos L=0.45u W=0.15u AS=0.0555p
+ AD=0.1005p PS=0.74u PD=1.34u rfmode=0
M$2593 \$410 WWL[4] WBL[4] GND sg13_hv_nmos L=0.45u W=0.15u AS=0.1005p
+ AD=0.0555p PS=1.34u PD=0.74u rfmode=0
M$2594 WBL[4] WWL[5] \$488 GND sg13_hv_nmos L=0.45u W=0.15u AS=0.0555p
+ AD=0.1005p PS=0.74u PD=1.34u rfmode=0
M$2595 \$411 WWL[4] WBL[5] GND sg13_hv_nmos L=0.45u W=0.15u AS=0.1005p
+ AD=0.0555p PS=1.34u PD=0.74u rfmode=0
M$2596 WBL[5] WWL[5] \$489 GND sg13_hv_nmos L=0.45u W=0.15u AS=0.0555p
+ AD=0.1005p PS=0.74u PD=1.34u rfmode=0
M$2597 \$412 WWL[4] WBL[6] GND sg13_hv_nmos L=0.45u W=0.15u AS=0.1005p
+ AD=0.0555p PS=1.34u PD=0.74u rfmode=0
M$2598 WBL[6] WWL[5] \$490 GND sg13_hv_nmos L=0.45u W=0.15u AS=0.0555p
+ AD=0.1005p PS=0.74u PD=1.34u rfmode=0
M$2599 \$413 WWL[4] WBL[7] GND sg13_hv_nmos L=0.45u W=0.15u AS=0.1005p
+ AD=0.0555p PS=1.34u PD=0.74u rfmode=0
M$2600 WBL[7] WWL[5] \$491 GND sg13_hv_nmos L=0.45u W=0.15u AS=0.0555p
+ AD=0.1005p PS=0.74u PD=1.34u rfmode=0
M$2601 \$414 WWL[4] WBL[8] GND sg13_hv_nmos L=0.45u W=0.15u AS=0.1005p
+ AD=0.0555p PS=1.34u PD=0.74u rfmode=0
M$2602 WBL[8] WWL[5] \$492 GND sg13_hv_nmos L=0.45u W=0.15u AS=0.0555p
+ AD=0.1005p PS=0.74u PD=1.34u rfmode=0
M$2603 \$415 WWL[4] WBL[9] GND sg13_hv_nmos L=0.45u W=0.15u AS=0.1005p
+ AD=0.0555p PS=1.34u PD=0.74u rfmode=0
M$2604 WBL[9] WWL[5] \$493 GND sg13_hv_nmos L=0.45u W=0.15u AS=0.0555p
+ AD=0.1005p PS=0.74u PD=1.34u rfmode=0
M$2605 \$416 WWL[4] WBL[10] GND sg13_hv_nmos L=0.45u W=0.15u AS=0.1005p
+ AD=0.0555p PS=1.34u PD=0.74u rfmode=0
M$2606 WBL[10] WWL[5] \$494 GND sg13_hv_nmos L=0.45u W=0.15u AS=0.0555p
+ AD=0.1005p PS=0.74u PD=1.34u rfmode=0
M$2607 \$417 WWL[4] WBL[11] GND sg13_hv_nmos L=0.45u W=0.15u AS=0.1005p
+ AD=0.0555p PS=1.34u PD=0.74u rfmode=0
M$2608 WBL[11] WWL[5] \$495 GND sg13_hv_nmos L=0.45u W=0.15u AS=0.0555p
+ AD=0.1005p PS=0.74u PD=1.34u rfmode=0
M$2609 \$418 WWL[4] WBL[12] GND sg13_hv_nmos L=0.45u W=0.15u AS=0.1005p
+ AD=0.0555p PS=1.34u PD=0.74u rfmode=0
M$2610 WBL[12] WWL[5] \$496 GND sg13_hv_nmos L=0.45u W=0.15u AS=0.0555p
+ AD=0.1005p PS=0.74u PD=1.34u rfmode=0
M$2611 \$419 WWL[4] WBL[13] GND sg13_hv_nmos L=0.45u W=0.15u AS=0.1005p
+ AD=0.0555p PS=1.34u PD=0.74u rfmode=0
M$2612 WBL[13] WWL[5] \$497 GND sg13_hv_nmos L=0.45u W=0.15u AS=0.0555p
+ AD=0.1005p PS=0.74u PD=1.34u rfmode=0
M$2613 \$420 WWL[4] WBL[14] GND sg13_hv_nmos L=0.45u W=0.15u AS=0.1005p
+ AD=0.0555p PS=1.34u PD=0.74u rfmode=0
M$2614 WBL[14] WWL[5] \$498 GND sg13_hv_nmos L=0.45u W=0.15u AS=0.0555p
+ AD=0.1005p PS=0.74u PD=1.34u rfmode=0
M$2615 \$421 WWL[4] WBL[15] GND sg13_hv_nmos L=0.45u W=0.15u AS=0.1005p
+ AD=0.0555p PS=1.34u PD=0.74u rfmode=0
M$2616 WBL[15] WWL[5] \$499 GND sg13_hv_nmos L=0.45u W=0.15u AS=0.0555p
+ AD=0.1005p PS=0.74u PD=1.34u rfmode=0
M$2617 \$422 WWL[4] WBL[16] GND sg13_hv_nmos L=0.45u W=0.15u AS=0.1005p
+ AD=0.0555p PS=1.34u PD=0.74u rfmode=0
M$2618 WBL[16] WWL[5] \$500 GND sg13_hv_nmos L=0.45u W=0.15u AS=0.0555p
+ AD=0.1005p PS=0.74u PD=1.34u rfmode=0
M$2619 \$423 WWL[4] WBL[17] GND sg13_hv_nmos L=0.45u W=0.15u AS=0.1005p
+ AD=0.0555p PS=1.34u PD=0.74u rfmode=0
M$2620 WBL[17] WWL[5] \$501 GND sg13_hv_nmos L=0.45u W=0.15u AS=0.0555p
+ AD=0.1005p PS=0.74u PD=1.34u rfmode=0
M$2621 \$424 WWL[4] WBL[18] GND sg13_hv_nmos L=0.45u W=0.15u AS=0.1005p
+ AD=0.0555p PS=1.34u PD=0.74u rfmode=0
M$2622 WBL[18] WWL[5] \$502 GND sg13_hv_nmos L=0.45u W=0.15u AS=0.0555p
+ AD=0.1005p PS=0.74u PD=1.34u rfmode=0
M$2623 \$425 WWL[4] WBL[19] GND sg13_hv_nmos L=0.45u W=0.15u AS=0.1005p
+ AD=0.0555p PS=1.34u PD=0.74u rfmode=0
M$2624 WBL[19] WWL[5] \$503 GND sg13_hv_nmos L=0.45u W=0.15u AS=0.0555p
+ AD=0.1005p PS=0.74u PD=1.34u rfmode=0
M$2625 \$426 WWL[4] WBL[20] GND sg13_hv_nmos L=0.45u W=0.15u AS=0.1005p
+ AD=0.0555p PS=1.34u PD=0.74u rfmode=0
M$2626 WBL[20] WWL[5] \$504 GND sg13_hv_nmos L=0.45u W=0.15u AS=0.0555p
+ AD=0.1005p PS=0.74u PD=1.34u rfmode=0
M$2627 \$427 WWL[4] WBL[21] GND sg13_hv_nmos L=0.45u W=0.15u AS=0.1005p
+ AD=0.0555p PS=1.34u PD=0.74u rfmode=0
M$2628 WBL[21] WWL[5] \$505 GND sg13_hv_nmos L=0.45u W=0.15u AS=0.0555p
+ AD=0.1005p PS=0.74u PD=1.34u rfmode=0
M$2629 \$428 WWL[4] WBL[22] GND sg13_hv_nmos L=0.45u W=0.15u AS=0.1005p
+ AD=0.0555p PS=1.34u PD=0.74u rfmode=0
M$2630 WBL[22] WWL[5] \$506 GND sg13_hv_nmos L=0.45u W=0.15u AS=0.0555p
+ AD=0.1005p PS=0.74u PD=1.34u rfmode=0
M$2631 \$429 WWL[4] WBL[23] GND sg13_hv_nmos L=0.45u W=0.15u AS=0.1005p
+ AD=0.0555p PS=1.34u PD=0.74u rfmode=0
M$2632 WBL[23] WWL[5] \$507 GND sg13_hv_nmos L=0.45u W=0.15u AS=0.0555p
+ AD=0.1005p PS=0.74u PD=1.34u rfmode=0
M$2633 \$430 WWL[4] WBL[24] GND sg13_hv_nmos L=0.45u W=0.15u AS=0.1005p
+ AD=0.0555p PS=1.34u PD=0.74u rfmode=0
M$2634 WBL[24] WWL[5] \$508 GND sg13_hv_nmos L=0.45u W=0.15u AS=0.0555p
+ AD=0.1005p PS=0.74u PD=1.34u rfmode=0
M$2635 \$431 WWL[4] WBL[25] GND sg13_hv_nmos L=0.45u W=0.15u AS=0.1005p
+ AD=0.0555p PS=1.34u PD=0.74u rfmode=0
M$2636 WBL[25] WWL[5] \$509 GND sg13_hv_nmos L=0.45u W=0.15u AS=0.0555p
+ AD=0.1005p PS=0.74u PD=1.34u rfmode=0
M$2637 \$432 WWL[4] WBL[26] GND sg13_hv_nmos L=0.45u W=0.15u AS=0.1005p
+ AD=0.0555p PS=1.34u PD=0.74u rfmode=0
M$2638 WBL[26] WWL[5] \$510 GND sg13_hv_nmos L=0.45u W=0.15u AS=0.0555p
+ AD=0.1005p PS=0.74u PD=1.34u rfmode=0
M$2639 \$433 WWL[4] WBL[27] GND sg13_hv_nmos L=0.45u W=0.15u AS=0.1005p
+ AD=0.0555p PS=1.34u PD=0.74u rfmode=0
M$2640 WBL[27] WWL[5] \$511 GND sg13_hv_nmos L=0.45u W=0.15u AS=0.0555p
+ AD=0.1005p PS=0.74u PD=1.34u rfmode=0
M$2641 \$434 WWL[4] WBL[28] GND sg13_hv_nmos L=0.45u W=0.15u AS=0.1005p
+ AD=0.0555p PS=1.34u PD=0.74u rfmode=0
M$2642 WBL[28] WWL[5] \$512 GND sg13_hv_nmos L=0.45u W=0.15u AS=0.0555p
+ AD=0.1005p PS=0.74u PD=1.34u rfmode=0
M$2643 \$435 WWL[4] WBL[29] GND sg13_hv_nmos L=0.45u W=0.15u AS=0.1005p
+ AD=0.0555p PS=1.34u PD=0.74u rfmode=0
M$2644 WBL[29] WWL[5] \$513 GND sg13_hv_nmos L=0.45u W=0.15u AS=0.0555p
+ AD=0.1005p PS=0.74u PD=1.34u rfmode=0
M$2645 \$436 WWL[4] WBL[30] GND sg13_hv_nmos L=0.45u W=0.15u AS=0.1005p
+ AD=0.0555p PS=1.34u PD=0.74u rfmode=0
M$2646 WBL[30] WWL[5] \$514 GND sg13_hv_nmos L=0.45u W=0.15u AS=0.0555p
+ AD=0.1005p PS=0.74u PD=1.34u rfmode=0
M$2647 \$437 WWL[4] WBL[31] GND sg13_hv_nmos L=0.45u W=0.15u AS=0.1005p
+ AD=0.0555p PS=1.34u PD=0.74u rfmode=0
M$2648 WBL[31] WWL[5] \$515 GND sg13_hv_nmos L=0.45u W=0.15u AS=0.0555p
+ AD=0.1005p PS=0.74u PD=1.34u rfmode=0
M$2649 \$438 WWL[4] WBL[32] GND sg13_hv_nmos L=0.45u W=0.15u AS=0.1005p
+ AD=0.0555p PS=1.34u PD=0.74u rfmode=0
M$2650 WBL[32] WWL[5] \$516 GND sg13_hv_nmos L=0.45u W=0.15u AS=0.0555p
+ AD=0.1005p PS=0.74u PD=1.34u rfmode=0
M$2651 \$439 WWL[4] WBL[33] GND sg13_hv_nmos L=0.45u W=0.15u AS=0.1005p
+ AD=0.0555p PS=1.34u PD=0.74u rfmode=0
M$2652 WBL[33] WWL[5] \$517 GND sg13_hv_nmos L=0.45u W=0.15u AS=0.0555p
+ AD=0.1005p PS=0.74u PD=1.34u rfmode=0
M$2653 \$440 WWL[4] WBL[34] GND sg13_hv_nmos L=0.45u W=0.15u AS=0.1005p
+ AD=0.0555p PS=1.34u PD=0.74u rfmode=0
M$2654 WBL[34] WWL[5] \$518 GND sg13_hv_nmos L=0.45u W=0.15u AS=0.0555p
+ AD=0.1005p PS=0.74u PD=1.34u rfmode=0
M$2655 \$441 WWL[4] WBL[35] GND sg13_hv_nmos L=0.45u W=0.15u AS=0.1005p
+ AD=0.0555p PS=1.34u PD=0.74u rfmode=0
M$2656 WBL[35] WWL[5] \$519 GND sg13_hv_nmos L=0.45u W=0.15u AS=0.0555p
+ AD=0.1005p PS=0.74u PD=1.34u rfmode=0
M$2657 \$442 WWL[4] WBL[36] GND sg13_hv_nmos L=0.45u W=0.15u AS=0.1005p
+ AD=0.0555p PS=1.34u PD=0.74u rfmode=0
M$2658 WBL[36] WWL[5] \$520 GND sg13_hv_nmos L=0.45u W=0.15u AS=0.0555p
+ AD=0.1005p PS=0.74u PD=1.34u rfmode=0
M$2659 \$443 WWL[4] WBL[37] GND sg13_hv_nmos L=0.45u W=0.15u AS=0.1005p
+ AD=0.0555p PS=1.34u PD=0.74u rfmode=0
M$2660 WBL[37] WWL[5] \$521 GND sg13_hv_nmos L=0.45u W=0.15u AS=0.0555p
+ AD=0.1005p PS=0.74u PD=1.34u rfmode=0
M$2661 \$569 WWL[6] WBL[0] GND sg13_hv_nmos L=0.45u W=0.15u AS=0.1005p
+ AD=0.0555p PS=1.34u PD=0.74u rfmode=0
M$2662 WBL[0] WWL[7] \$647 GND sg13_hv_nmos L=0.45u W=0.15u AS=0.0555p
+ AD=0.1005p PS=0.74u PD=1.34u rfmode=0
M$2663 \$570 WWL[6] WBL[1] GND sg13_hv_nmos L=0.45u W=0.15u AS=0.1005p
+ AD=0.0555p PS=1.34u PD=0.74u rfmode=0
M$2664 WBL[1] WWL[7] \$648 GND sg13_hv_nmos L=0.45u W=0.15u AS=0.0555p
+ AD=0.1005p PS=0.74u PD=1.34u rfmode=0
M$2665 \$571 WWL[6] WBL[2] GND sg13_hv_nmos L=0.45u W=0.15u AS=0.1005p
+ AD=0.0555p PS=1.34u PD=0.74u rfmode=0
M$2666 WBL[2] WWL[7] \$649 GND sg13_hv_nmos L=0.45u W=0.15u AS=0.0555p
+ AD=0.1005p PS=0.74u PD=1.34u rfmode=0
M$2667 \$572 WWL[6] WBL[3] GND sg13_hv_nmos L=0.45u W=0.15u AS=0.1005p
+ AD=0.0555p PS=1.34u PD=0.74u rfmode=0
M$2668 WBL[3] WWL[7] \$650 GND sg13_hv_nmos L=0.45u W=0.15u AS=0.0555p
+ AD=0.1005p PS=0.74u PD=1.34u rfmode=0
M$2669 \$573 WWL[6] WBL[4] GND sg13_hv_nmos L=0.45u W=0.15u AS=0.1005p
+ AD=0.0555p PS=1.34u PD=0.74u rfmode=0
M$2670 WBL[4] WWL[7] \$651 GND sg13_hv_nmos L=0.45u W=0.15u AS=0.0555p
+ AD=0.1005p PS=0.74u PD=1.34u rfmode=0
M$2671 \$574 WWL[6] WBL[5] GND sg13_hv_nmos L=0.45u W=0.15u AS=0.1005p
+ AD=0.0555p PS=1.34u PD=0.74u rfmode=0
M$2672 WBL[5] WWL[7] \$652 GND sg13_hv_nmos L=0.45u W=0.15u AS=0.0555p
+ AD=0.1005p PS=0.74u PD=1.34u rfmode=0
M$2673 \$575 WWL[6] WBL[6] GND sg13_hv_nmos L=0.45u W=0.15u AS=0.1005p
+ AD=0.0555p PS=1.34u PD=0.74u rfmode=0
M$2674 WBL[6] WWL[7] \$653 GND sg13_hv_nmos L=0.45u W=0.15u AS=0.0555p
+ AD=0.1005p PS=0.74u PD=1.34u rfmode=0
M$2675 \$576 WWL[6] WBL[7] GND sg13_hv_nmos L=0.45u W=0.15u AS=0.1005p
+ AD=0.0555p PS=1.34u PD=0.74u rfmode=0
M$2676 WBL[7] WWL[7] \$654 GND sg13_hv_nmos L=0.45u W=0.15u AS=0.0555p
+ AD=0.1005p PS=0.74u PD=1.34u rfmode=0
M$2677 \$577 WWL[6] WBL[8] GND sg13_hv_nmos L=0.45u W=0.15u AS=0.1005p
+ AD=0.0555p PS=1.34u PD=0.74u rfmode=0
M$2678 WBL[8] WWL[7] \$655 GND sg13_hv_nmos L=0.45u W=0.15u AS=0.0555p
+ AD=0.1005p PS=0.74u PD=1.34u rfmode=0
M$2679 \$578 WWL[6] WBL[9] GND sg13_hv_nmos L=0.45u W=0.15u AS=0.1005p
+ AD=0.0555p PS=1.34u PD=0.74u rfmode=0
M$2680 WBL[9] WWL[7] \$656 GND sg13_hv_nmos L=0.45u W=0.15u AS=0.0555p
+ AD=0.1005p PS=0.74u PD=1.34u rfmode=0
M$2681 \$579 WWL[6] WBL[10] GND sg13_hv_nmos L=0.45u W=0.15u AS=0.1005p
+ AD=0.0555p PS=1.34u PD=0.74u rfmode=0
M$2682 WBL[10] WWL[7] \$657 GND sg13_hv_nmos L=0.45u W=0.15u AS=0.0555p
+ AD=0.1005p PS=0.74u PD=1.34u rfmode=0
M$2683 \$580 WWL[6] WBL[11] GND sg13_hv_nmos L=0.45u W=0.15u AS=0.1005p
+ AD=0.0555p PS=1.34u PD=0.74u rfmode=0
M$2684 WBL[11] WWL[7] \$658 GND sg13_hv_nmos L=0.45u W=0.15u AS=0.0555p
+ AD=0.1005p PS=0.74u PD=1.34u rfmode=0
M$2685 \$581 WWL[6] WBL[12] GND sg13_hv_nmos L=0.45u W=0.15u AS=0.1005p
+ AD=0.0555p PS=1.34u PD=0.74u rfmode=0
M$2686 WBL[12] WWL[7] \$659 GND sg13_hv_nmos L=0.45u W=0.15u AS=0.0555p
+ AD=0.1005p PS=0.74u PD=1.34u rfmode=0
M$2687 \$582 WWL[6] WBL[13] GND sg13_hv_nmos L=0.45u W=0.15u AS=0.1005p
+ AD=0.0555p PS=1.34u PD=0.74u rfmode=0
M$2688 WBL[13] WWL[7] \$660 GND sg13_hv_nmos L=0.45u W=0.15u AS=0.0555p
+ AD=0.1005p PS=0.74u PD=1.34u rfmode=0
M$2689 \$583 WWL[6] WBL[14] GND sg13_hv_nmos L=0.45u W=0.15u AS=0.1005p
+ AD=0.0555p PS=1.34u PD=0.74u rfmode=0
M$2690 WBL[14] WWL[7] \$661 GND sg13_hv_nmos L=0.45u W=0.15u AS=0.0555p
+ AD=0.1005p PS=0.74u PD=1.34u rfmode=0
M$2691 \$584 WWL[6] WBL[15] GND sg13_hv_nmos L=0.45u W=0.15u AS=0.1005p
+ AD=0.0555p PS=1.34u PD=0.74u rfmode=0
M$2692 WBL[15] WWL[7] \$662 GND sg13_hv_nmos L=0.45u W=0.15u AS=0.0555p
+ AD=0.1005p PS=0.74u PD=1.34u rfmode=0
M$2693 \$585 WWL[6] WBL[16] GND sg13_hv_nmos L=0.45u W=0.15u AS=0.1005p
+ AD=0.0555p PS=1.34u PD=0.74u rfmode=0
M$2694 WBL[16] WWL[7] \$663 GND sg13_hv_nmos L=0.45u W=0.15u AS=0.0555p
+ AD=0.1005p PS=0.74u PD=1.34u rfmode=0
M$2695 \$586 WWL[6] WBL[17] GND sg13_hv_nmos L=0.45u W=0.15u AS=0.1005p
+ AD=0.0555p PS=1.34u PD=0.74u rfmode=0
M$2696 WBL[17] WWL[7] \$664 GND sg13_hv_nmos L=0.45u W=0.15u AS=0.0555p
+ AD=0.1005p PS=0.74u PD=1.34u rfmode=0
M$2697 \$587 WWL[6] WBL[18] GND sg13_hv_nmos L=0.45u W=0.15u AS=0.1005p
+ AD=0.0555p PS=1.34u PD=0.74u rfmode=0
M$2698 WBL[18] WWL[7] \$665 GND sg13_hv_nmos L=0.45u W=0.15u AS=0.0555p
+ AD=0.1005p PS=0.74u PD=1.34u rfmode=0
M$2699 \$588 WWL[6] WBL[19] GND sg13_hv_nmos L=0.45u W=0.15u AS=0.1005p
+ AD=0.0555p PS=1.34u PD=0.74u rfmode=0
M$2700 WBL[19] WWL[7] \$666 GND sg13_hv_nmos L=0.45u W=0.15u AS=0.0555p
+ AD=0.1005p PS=0.74u PD=1.34u rfmode=0
M$2701 \$589 WWL[6] WBL[20] GND sg13_hv_nmos L=0.45u W=0.15u AS=0.1005p
+ AD=0.0555p PS=1.34u PD=0.74u rfmode=0
M$2702 WBL[20] WWL[7] \$667 GND sg13_hv_nmos L=0.45u W=0.15u AS=0.0555p
+ AD=0.1005p PS=0.74u PD=1.34u rfmode=0
M$2703 \$590 WWL[6] WBL[21] GND sg13_hv_nmos L=0.45u W=0.15u AS=0.1005p
+ AD=0.0555p PS=1.34u PD=0.74u rfmode=0
M$2704 WBL[21] WWL[7] \$668 GND sg13_hv_nmos L=0.45u W=0.15u AS=0.0555p
+ AD=0.1005p PS=0.74u PD=1.34u rfmode=0
M$2705 \$591 WWL[6] WBL[22] GND sg13_hv_nmos L=0.45u W=0.15u AS=0.1005p
+ AD=0.0555p PS=1.34u PD=0.74u rfmode=0
M$2706 WBL[22] WWL[7] \$669 GND sg13_hv_nmos L=0.45u W=0.15u AS=0.0555p
+ AD=0.1005p PS=0.74u PD=1.34u rfmode=0
M$2707 \$592 WWL[6] WBL[23] GND sg13_hv_nmos L=0.45u W=0.15u AS=0.1005p
+ AD=0.0555p PS=1.34u PD=0.74u rfmode=0
M$2708 WBL[23] WWL[7] \$670 GND sg13_hv_nmos L=0.45u W=0.15u AS=0.0555p
+ AD=0.1005p PS=0.74u PD=1.34u rfmode=0
M$2709 \$593 WWL[6] WBL[24] GND sg13_hv_nmos L=0.45u W=0.15u AS=0.1005p
+ AD=0.0555p PS=1.34u PD=0.74u rfmode=0
M$2710 WBL[24] WWL[7] \$671 GND sg13_hv_nmos L=0.45u W=0.15u AS=0.0555p
+ AD=0.1005p PS=0.74u PD=1.34u rfmode=0
M$2711 \$594 WWL[6] WBL[25] GND sg13_hv_nmos L=0.45u W=0.15u AS=0.1005p
+ AD=0.0555p PS=1.34u PD=0.74u rfmode=0
M$2712 WBL[25] WWL[7] \$672 GND sg13_hv_nmos L=0.45u W=0.15u AS=0.0555p
+ AD=0.1005p PS=0.74u PD=1.34u rfmode=0
M$2713 \$595 WWL[6] WBL[26] GND sg13_hv_nmos L=0.45u W=0.15u AS=0.1005p
+ AD=0.0555p PS=1.34u PD=0.74u rfmode=0
M$2714 WBL[26] WWL[7] \$673 GND sg13_hv_nmos L=0.45u W=0.15u AS=0.0555p
+ AD=0.1005p PS=0.74u PD=1.34u rfmode=0
M$2715 \$596 WWL[6] WBL[27] GND sg13_hv_nmos L=0.45u W=0.15u AS=0.1005p
+ AD=0.0555p PS=1.34u PD=0.74u rfmode=0
M$2716 WBL[27] WWL[7] \$674 GND sg13_hv_nmos L=0.45u W=0.15u AS=0.0555p
+ AD=0.1005p PS=0.74u PD=1.34u rfmode=0
M$2717 \$597 WWL[6] WBL[28] GND sg13_hv_nmos L=0.45u W=0.15u AS=0.1005p
+ AD=0.0555p PS=1.34u PD=0.74u rfmode=0
M$2718 WBL[28] WWL[7] \$675 GND sg13_hv_nmos L=0.45u W=0.15u AS=0.0555p
+ AD=0.1005p PS=0.74u PD=1.34u rfmode=0
M$2719 \$598 WWL[6] WBL[29] GND sg13_hv_nmos L=0.45u W=0.15u AS=0.1005p
+ AD=0.0555p PS=1.34u PD=0.74u rfmode=0
M$2720 WBL[29] WWL[7] \$676 GND sg13_hv_nmos L=0.45u W=0.15u AS=0.0555p
+ AD=0.1005p PS=0.74u PD=1.34u rfmode=0
M$2721 \$599 WWL[6] WBL[30] GND sg13_hv_nmos L=0.45u W=0.15u AS=0.1005p
+ AD=0.0555p PS=1.34u PD=0.74u rfmode=0
M$2722 WBL[30] WWL[7] \$677 GND sg13_hv_nmos L=0.45u W=0.15u AS=0.0555p
+ AD=0.1005p PS=0.74u PD=1.34u rfmode=0
M$2723 \$600 WWL[6] WBL[31] GND sg13_hv_nmos L=0.45u W=0.15u AS=0.1005p
+ AD=0.0555p PS=1.34u PD=0.74u rfmode=0
M$2724 WBL[31] WWL[7] \$678 GND sg13_hv_nmos L=0.45u W=0.15u AS=0.0555p
+ AD=0.1005p PS=0.74u PD=1.34u rfmode=0
M$2725 \$601 WWL[6] WBL[32] GND sg13_hv_nmos L=0.45u W=0.15u AS=0.1005p
+ AD=0.0555p PS=1.34u PD=0.74u rfmode=0
M$2726 WBL[32] WWL[7] \$679 GND sg13_hv_nmos L=0.45u W=0.15u AS=0.0555p
+ AD=0.1005p PS=0.74u PD=1.34u rfmode=0
M$2727 \$602 WWL[6] WBL[33] GND sg13_hv_nmos L=0.45u W=0.15u AS=0.1005p
+ AD=0.0555p PS=1.34u PD=0.74u rfmode=0
M$2728 WBL[33] WWL[7] \$680 GND sg13_hv_nmos L=0.45u W=0.15u AS=0.0555p
+ AD=0.1005p PS=0.74u PD=1.34u rfmode=0
M$2729 \$603 WWL[6] WBL[34] GND sg13_hv_nmos L=0.45u W=0.15u AS=0.1005p
+ AD=0.0555p PS=1.34u PD=0.74u rfmode=0
M$2730 WBL[34] WWL[7] \$681 GND sg13_hv_nmos L=0.45u W=0.15u AS=0.0555p
+ AD=0.1005p PS=0.74u PD=1.34u rfmode=0
M$2731 \$604 WWL[6] WBL[35] GND sg13_hv_nmos L=0.45u W=0.15u AS=0.1005p
+ AD=0.0555p PS=1.34u PD=0.74u rfmode=0
M$2732 WBL[35] WWL[7] \$682 GND sg13_hv_nmos L=0.45u W=0.15u AS=0.0555p
+ AD=0.1005p PS=0.74u PD=1.34u rfmode=0
M$2733 \$605 WWL[6] WBL[36] GND sg13_hv_nmos L=0.45u W=0.15u AS=0.1005p
+ AD=0.0555p PS=1.34u PD=0.74u rfmode=0
M$2734 WBL[36] WWL[7] \$683 GND sg13_hv_nmos L=0.45u W=0.15u AS=0.0555p
+ AD=0.1005p PS=0.74u PD=1.34u rfmode=0
M$2735 \$606 WWL[6] WBL[37] GND sg13_hv_nmos L=0.45u W=0.15u AS=0.1005p
+ AD=0.0555p PS=1.34u PD=0.74u rfmode=0
M$2736 WBL[37] WWL[7] \$684 GND sg13_hv_nmos L=0.45u W=0.15u AS=0.0555p
+ AD=0.1005p PS=0.74u PD=1.34u rfmode=0
M$2737 \$732 WWL[8] WBL[0] GND sg13_hv_nmos L=0.45u W=0.15u AS=0.1005p
+ AD=0.0555p PS=1.34u PD=0.74u rfmode=0
M$2738 WBL[0] WWL[9] \$810 GND sg13_hv_nmos L=0.45u W=0.15u AS=0.0555p
+ AD=0.1005p PS=0.74u PD=1.34u rfmode=0
M$2739 \$733 WWL[8] WBL[1] GND sg13_hv_nmos L=0.45u W=0.15u AS=0.1005p
+ AD=0.0555p PS=1.34u PD=0.74u rfmode=0
M$2740 WBL[1] WWL[9] \$811 GND sg13_hv_nmos L=0.45u W=0.15u AS=0.0555p
+ AD=0.1005p PS=0.74u PD=1.34u rfmode=0
M$2741 \$734 WWL[8] WBL[2] GND sg13_hv_nmos L=0.45u W=0.15u AS=0.1005p
+ AD=0.0555p PS=1.34u PD=0.74u rfmode=0
M$2742 WBL[2] WWL[9] \$812 GND sg13_hv_nmos L=0.45u W=0.15u AS=0.0555p
+ AD=0.1005p PS=0.74u PD=1.34u rfmode=0
M$2743 \$735 WWL[8] WBL[3] GND sg13_hv_nmos L=0.45u W=0.15u AS=0.1005p
+ AD=0.0555p PS=1.34u PD=0.74u rfmode=0
M$2744 WBL[3] WWL[9] \$813 GND sg13_hv_nmos L=0.45u W=0.15u AS=0.0555p
+ AD=0.1005p PS=0.74u PD=1.34u rfmode=0
M$2745 \$736 WWL[8] WBL[4] GND sg13_hv_nmos L=0.45u W=0.15u AS=0.1005p
+ AD=0.0555p PS=1.34u PD=0.74u rfmode=0
M$2746 WBL[4] WWL[9] \$814 GND sg13_hv_nmos L=0.45u W=0.15u AS=0.0555p
+ AD=0.1005p PS=0.74u PD=1.34u rfmode=0
M$2747 \$737 WWL[8] WBL[5] GND sg13_hv_nmos L=0.45u W=0.15u AS=0.1005p
+ AD=0.0555p PS=1.34u PD=0.74u rfmode=0
M$2748 WBL[5] WWL[9] \$815 GND sg13_hv_nmos L=0.45u W=0.15u AS=0.0555p
+ AD=0.1005p PS=0.74u PD=1.34u rfmode=0
M$2749 \$738 WWL[8] WBL[6] GND sg13_hv_nmos L=0.45u W=0.15u AS=0.1005p
+ AD=0.0555p PS=1.34u PD=0.74u rfmode=0
M$2750 WBL[6] WWL[9] \$816 GND sg13_hv_nmos L=0.45u W=0.15u AS=0.0555p
+ AD=0.1005p PS=0.74u PD=1.34u rfmode=0
M$2751 \$739 WWL[8] WBL[7] GND sg13_hv_nmos L=0.45u W=0.15u AS=0.1005p
+ AD=0.0555p PS=1.34u PD=0.74u rfmode=0
M$2752 WBL[7] WWL[9] \$817 GND sg13_hv_nmos L=0.45u W=0.15u AS=0.0555p
+ AD=0.1005p PS=0.74u PD=1.34u rfmode=0
M$2753 \$740 WWL[8] WBL[8] GND sg13_hv_nmos L=0.45u W=0.15u AS=0.1005p
+ AD=0.0555p PS=1.34u PD=0.74u rfmode=0
M$2754 WBL[8] WWL[9] \$818 GND sg13_hv_nmos L=0.45u W=0.15u AS=0.0555p
+ AD=0.1005p PS=0.74u PD=1.34u rfmode=0
M$2755 \$741 WWL[8] WBL[9] GND sg13_hv_nmos L=0.45u W=0.15u AS=0.1005p
+ AD=0.0555p PS=1.34u PD=0.74u rfmode=0
M$2756 WBL[9] WWL[9] \$819 GND sg13_hv_nmos L=0.45u W=0.15u AS=0.0555p
+ AD=0.1005p PS=0.74u PD=1.34u rfmode=0
M$2757 \$742 WWL[8] WBL[10] GND sg13_hv_nmos L=0.45u W=0.15u AS=0.1005p
+ AD=0.0555p PS=1.34u PD=0.74u rfmode=0
M$2758 WBL[10] WWL[9] \$820 GND sg13_hv_nmos L=0.45u W=0.15u AS=0.0555p
+ AD=0.1005p PS=0.74u PD=1.34u rfmode=0
M$2759 \$743 WWL[8] WBL[11] GND sg13_hv_nmos L=0.45u W=0.15u AS=0.1005p
+ AD=0.0555p PS=1.34u PD=0.74u rfmode=0
M$2760 WBL[11] WWL[9] \$821 GND sg13_hv_nmos L=0.45u W=0.15u AS=0.0555p
+ AD=0.1005p PS=0.74u PD=1.34u rfmode=0
M$2761 \$744 WWL[8] WBL[12] GND sg13_hv_nmos L=0.45u W=0.15u AS=0.1005p
+ AD=0.0555p PS=1.34u PD=0.74u rfmode=0
M$2762 WBL[12] WWL[9] \$822 GND sg13_hv_nmos L=0.45u W=0.15u AS=0.0555p
+ AD=0.1005p PS=0.74u PD=1.34u rfmode=0
M$2763 \$745 WWL[8] WBL[13] GND sg13_hv_nmos L=0.45u W=0.15u AS=0.1005p
+ AD=0.0555p PS=1.34u PD=0.74u rfmode=0
M$2764 WBL[13] WWL[9] \$823 GND sg13_hv_nmos L=0.45u W=0.15u AS=0.0555p
+ AD=0.1005p PS=0.74u PD=1.34u rfmode=0
M$2765 \$746 WWL[8] WBL[14] GND sg13_hv_nmos L=0.45u W=0.15u AS=0.1005p
+ AD=0.0555p PS=1.34u PD=0.74u rfmode=0
M$2766 WBL[14] WWL[9] \$824 GND sg13_hv_nmos L=0.45u W=0.15u AS=0.0555p
+ AD=0.1005p PS=0.74u PD=1.34u rfmode=0
M$2767 \$747 WWL[8] WBL[15] GND sg13_hv_nmos L=0.45u W=0.15u AS=0.1005p
+ AD=0.0555p PS=1.34u PD=0.74u rfmode=0
M$2768 WBL[15] WWL[9] \$825 GND sg13_hv_nmos L=0.45u W=0.15u AS=0.0555p
+ AD=0.1005p PS=0.74u PD=1.34u rfmode=0
M$2769 \$748 WWL[8] WBL[16] GND sg13_hv_nmos L=0.45u W=0.15u AS=0.1005p
+ AD=0.0555p PS=1.34u PD=0.74u rfmode=0
M$2770 WBL[16] WWL[9] \$826 GND sg13_hv_nmos L=0.45u W=0.15u AS=0.0555p
+ AD=0.1005p PS=0.74u PD=1.34u rfmode=0
M$2771 \$749 WWL[8] WBL[17] GND sg13_hv_nmos L=0.45u W=0.15u AS=0.1005p
+ AD=0.0555p PS=1.34u PD=0.74u rfmode=0
M$2772 WBL[17] WWL[9] \$827 GND sg13_hv_nmos L=0.45u W=0.15u AS=0.0555p
+ AD=0.1005p PS=0.74u PD=1.34u rfmode=0
M$2773 \$750 WWL[8] WBL[18] GND sg13_hv_nmos L=0.45u W=0.15u AS=0.1005p
+ AD=0.0555p PS=1.34u PD=0.74u rfmode=0
M$2774 WBL[18] WWL[9] \$828 GND sg13_hv_nmos L=0.45u W=0.15u AS=0.0555p
+ AD=0.1005p PS=0.74u PD=1.34u rfmode=0
M$2775 \$751 WWL[8] WBL[19] GND sg13_hv_nmos L=0.45u W=0.15u AS=0.1005p
+ AD=0.0555p PS=1.34u PD=0.74u rfmode=0
M$2776 WBL[19] WWL[9] \$829 GND sg13_hv_nmos L=0.45u W=0.15u AS=0.0555p
+ AD=0.1005p PS=0.74u PD=1.34u rfmode=0
M$2777 \$752 WWL[8] WBL[20] GND sg13_hv_nmos L=0.45u W=0.15u AS=0.1005p
+ AD=0.0555p PS=1.34u PD=0.74u rfmode=0
M$2778 WBL[20] WWL[9] \$830 GND sg13_hv_nmos L=0.45u W=0.15u AS=0.0555p
+ AD=0.1005p PS=0.74u PD=1.34u rfmode=0
M$2779 \$753 WWL[8] WBL[21] GND sg13_hv_nmos L=0.45u W=0.15u AS=0.1005p
+ AD=0.0555p PS=1.34u PD=0.74u rfmode=0
M$2780 WBL[21] WWL[9] \$831 GND sg13_hv_nmos L=0.45u W=0.15u AS=0.0555p
+ AD=0.1005p PS=0.74u PD=1.34u rfmode=0
M$2781 \$754 WWL[8] WBL[22] GND sg13_hv_nmos L=0.45u W=0.15u AS=0.1005p
+ AD=0.0555p PS=1.34u PD=0.74u rfmode=0
M$2782 WBL[22] WWL[9] \$832 GND sg13_hv_nmos L=0.45u W=0.15u AS=0.0555p
+ AD=0.1005p PS=0.74u PD=1.34u rfmode=0
M$2783 \$755 WWL[8] WBL[23] GND sg13_hv_nmos L=0.45u W=0.15u AS=0.1005p
+ AD=0.0555p PS=1.34u PD=0.74u rfmode=0
M$2784 WBL[23] WWL[9] \$833 GND sg13_hv_nmos L=0.45u W=0.15u AS=0.0555p
+ AD=0.1005p PS=0.74u PD=1.34u rfmode=0
M$2785 \$756 WWL[8] WBL[24] GND sg13_hv_nmos L=0.45u W=0.15u AS=0.1005p
+ AD=0.0555p PS=1.34u PD=0.74u rfmode=0
M$2786 WBL[24] WWL[9] \$834 GND sg13_hv_nmos L=0.45u W=0.15u AS=0.0555p
+ AD=0.1005p PS=0.74u PD=1.34u rfmode=0
M$2787 \$757 WWL[8] WBL[25] GND sg13_hv_nmos L=0.45u W=0.15u AS=0.1005p
+ AD=0.0555p PS=1.34u PD=0.74u rfmode=0
M$2788 WBL[25] WWL[9] \$835 GND sg13_hv_nmos L=0.45u W=0.15u AS=0.0555p
+ AD=0.1005p PS=0.74u PD=1.34u rfmode=0
M$2789 \$758 WWL[8] WBL[26] GND sg13_hv_nmos L=0.45u W=0.15u AS=0.1005p
+ AD=0.0555p PS=1.34u PD=0.74u rfmode=0
M$2790 WBL[26] WWL[9] \$836 GND sg13_hv_nmos L=0.45u W=0.15u AS=0.0555p
+ AD=0.1005p PS=0.74u PD=1.34u rfmode=0
M$2791 \$759 WWL[8] WBL[27] GND sg13_hv_nmos L=0.45u W=0.15u AS=0.1005p
+ AD=0.0555p PS=1.34u PD=0.74u rfmode=0
M$2792 WBL[27] WWL[9] \$837 GND sg13_hv_nmos L=0.45u W=0.15u AS=0.0555p
+ AD=0.1005p PS=0.74u PD=1.34u rfmode=0
M$2793 \$760 WWL[8] WBL[28] GND sg13_hv_nmos L=0.45u W=0.15u AS=0.1005p
+ AD=0.0555p PS=1.34u PD=0.74u rfmode=0
M$2794 WBL[28] WWL[9] \$838 GND sg13_hv_nmos L=0.45u W=0.15u AS=0.0555p
+ AD=0.1005p PS=0.74u PD=1.34u rfmode=0
M$2795 \$761 WWL[8] WBL[29] GND sg13_hv_nmos L=0.45u W=0.15u AS=0.1005p
+ AD=0.0555p PS=1.34u PD=0.74u rfmode=0
M$2796 WBL[29] WWL[9] \$839 GND sg13_hv_nmos L=0.45u W=0.15u AS=0.0555p
+ AD=0.1005p PS=0.74u PD=1.34u rfmode=0
M$2797 \$762 WWL[8] WBL[30] GND sg13_hv_nmos L=0.45u W=0.15u AS=0.1005p
+ AD=0.0555p PS=1.34u PD=0.74u rfmode=0
M$2798 WBL[30] WWL[9] \$840 GND sg13_hv_nmos L=0.45u W=0.15u AS=0.0555p
+ AD=0.1005p PS=0.74u PD=1.34u rfmode=0
M$2799 \$763 WWL[8] WBL[31] GND sg13_hv_nmos L=0.45u W=0.15u AS=0.1005p
+ AD=0.0555p PS=1.34u PD=0.74u rfmode=0
M$2800 WBL[31] WWL[9] \$841 GND sg13_hv_nmos L=0.45u W=0.15u AS=0.0555p
+ AD=0.1005p PS=0.74u PD=1.34u rfmode=0
M$2801 \$764 WWL[8] WBL[32] GND sg13_hv_nmos L=0.45u W=0.15u AS=0.1005p
+ AD=0.0555p PS=1.34u PD=0.74u rfmode=0
M$2802 WBL[32] WWL[9] \$842 GND sg13_hv_nmos L=0.45u W=0.15u AS=0.0555p
+ AD=0.1005p PS=0.74u PD=1.34u rfmode=0
M$2803 \$765 WWL[8] WBL[33] GND sg13_hv_nmos L=0.45u W=0.15u AS=0.1005p
+ AD=0.0555p PS=1.34u PD=0.74u rfmode=0
M$2804 WBL[33] WWL[9] \$843 GND sg13_hv_nmos L=0.45u W=0.15u AS=0.0555p
+ AD=0.1005p PS=0.74u PD=1.34u rfmode=0
M$2805 \$766 WWL[8] WBL[34] GND sg13_hv_nmos L=0.45u W=0.15u AS=0.1005p
+ AD=0.0555p PS=1.34u PD=0.74u rfmode=0
M$2806 WBL[34] WWL[9] \$844 GND sg13_hv_nmos L=0.45u W=0.15u AS=0.0555p
+ AD=0.1005p PS=0.74u PD=1.34u rfmode=0
M$2807 \$767 WWL[8] WBL[35] GND sg13_hv_nmos L=0.45u W=0.15u AS=0.1005p
+ AD=0.0555p PS=1.34u PD=0.74u rfmode=0
M$2808 WBL[35] WWL[9] \$845 GND sg13_hv_nmos L=0.45u W=0.15u AS=0.0555p
+ AD=0.1005p PS=0.74u PD=1.34u rfmode=0
M$2809 \$768 WWL[8] WBL[36] GND sg13_hv_nmos L=0.45u W=0.15u AS=0.1005p
+ AD=0.0555p PS=1.34u PD=0.74u rfmode=0
M$2810 WBL[36] WWL[9] \$846 GND sg13_hv_nmos L=0.45u W=0.15u AS=0.0555p
+ AD=0.1005p PS=0.74u PD=1.34u rfmode=0
M$2811 \$769 WWL[8] WBL[37] GND sg13_hv_nmos L=0.45u W=0.15u AS=0.1005p
+ AD=0.0555p PS=1.34u PD=0.74u rfmode=0
M$2812 WBL[37] WWL[9] \$847 GND sg13_hv_nmos L=0.45u W=0.15u AS=0.0555p
+ AD=0.1005p PS=0.74u PD=1.34u rfmode=0
M$2813 \$895 WWL[10] WBL[0] GND sg13_hv_nmos L=0.45u W=0.15u AS=0.1005p
+ AD=0.0555p PS=1.34u PD=0.74u rfmode=0
M$2814 WBL[0] WWL[11] \$973 GND sg13_hv_nmos L=0.45u W=0.15u AS=0.0555p
+ AD=0.1005p PS=0.74u PD=1.34u rfmode=0
M$2815 \$896 WWL[10] WBL[1] GND sg13_hv_nmos L=0.45u W=0.15u AS=0.1005p
+ AD=0.0555p PS=1.34u PD=0.74u rfmode=0
M$2816 WBL[1] WWL[11] \$974 GND sg13_hv_nmos L=0.45u W=0.15u AS=0.0555p
+ AD=0.1005p PS=0.74u PD=1.34u rfmode=0
M$2817 \$897 WWL[10] WBL[2] GND sg13_hv_nmos L=0.45u W=0.15u AS=0.1005p
+ AD=0.0555p PS=1.34u PD=0.74u rfmode=0
M$2818 WBL[2] WWL[11] \$975 GND sg13_hv_nmos L=0.45u W=0.15u AS=0.0555p
+ AD=0.1005p PS=0.74u PD=1.34u rfmode=0
M$2819 \$898 WWL[10] WBL[3] GND sg13_hv_nmos L=0.45u W=0.15u AS=0.1005p
+ AD=0.0555p PS=1.34u PD=0.74u rfmode=0
M$2820 WBL[3] WWL[11] \$976 GND sg13_hv_nmos L=0.45u W=0.15u AS=0.0555p
+ AD=0.1005p PS=0.74u PD=1.34u rfmode=0
M$2821 \$899 WWL[10] WBL[4] GND sg13_hv_nmos L=0.45u W=0.15u AS=0.1005p
+ AD=0.0555p PS=1.34u PD=0.74u rfmode=0
M$2822 WBL[4] WWL[11] \$977 GND sg13_hv_nmos L=0.45u W=0.15u AS=0.0555p
+ AD=0.1005p PS=0.74u PD=1.34u rfmode=0
M$2823 \$900 WWL[10] WBL[5] GND sg13_hv_nmos L=0.45u W=0.15u AS=0.1005p
+ AD=0.0555p PS=1.34u PD=0.74u rfmode=0
M$2824 WBL[5] WWL[11] \$978 GND sg13_hv_nmos L=0.45u W=0.15u AS=0.0555p
+ AD=0.1005p PS=0.74u PD=1.34u rfmode=0
M$2825 \$901 WWL[10] WBL[6] GND sg13_hv_nmos L=0.45u W=0.15u AS=0.1005p
+ AD=0.0555p PS=1.34u PD=0.74u rfmode=0
M$2826 WBL[6] WWL[11] \$979 GND sg13_hv_nmos L=0.45u W=0.15u AS=0.0555p
+ AD=0.1005p PS=0.74u PD=1.34u rfmode=0
M$2827 \$902 WWL[10] WBL[7] GND sg13_hv_nmos L=0.45u W=0.15u AS=0.1005p
+ AD=0.0555p PS=1.34u PD=0.74u rfmode=0
M$2828 WBL[7] WWL[11] \$980 GND sg13_hv_nmos L=0.45u W=0.15u AS=0.0555p
+ AD=0.1005p PS=0.74u PD=1.34u rfmode=0
M$2829 \$903 WWL[10] WBL[8] GND sg13_hv_nmos L=0.45u W=0.15u AS=0.1005p
+ AD=0.0555p PS=1.34u PD=0.74u rfmode=0
M$2830 WBL[8] WWL[11] \$981 GND sg13_hv_nmos L=0.45u W=0.15u AS=0.0555p
+ AD=0.1005p PS=0.74u PD=1.34u rfmode=0
M$2831 \$904 WWL[10] WBL[9] GND sg13_hv_nmos L=0.45u W=0.15u AS=0.1005p
+ AD=0.0555p PS=1.34u PD=0.74u rfmode=0
M$2832 WBL[9] WWL[11] \$982 GND sg13_hv_nmos L=0.45u W=0.15u AS=0.0555p
+ AD=0.1005p PS=0.74u PD=1.34u rfmode=0
M$2833 \$905 WWL[10] WBL[10] GND sg13_hv_nmos L=0.45u W=0.15u AS=0.1005p
+ AD=0.0555p PS=1.34u PD=0.74u rfmode=0
M$2834 WBL[10] WWL[11] \$983 GND sg13_hv_nmos L=0.45u W=0.15u AS=0.0555p
+ AD=0.1005p PS=0.74u PD=1.34u rfmode=0
M$2835 \$906 WWL[10] WBL[11] GND sg13_hv_nmos L=0.45u W=0.15u AS=0.1005p
+ AD=0.0555p PS=1.34u PD=0.74u rfmode=0
M$2836 WBL[11] WWL[11] \$984 GND sg13_hv_nmos L=0.45u W=0.15u AS=0.0555p
+ AD=0.1005p PS=0.74u PD=1.34u rfmode=0
M$2837 \$907 WWL[10] WBL[12] GND sg13_hv_nmos L=0.45u W=0.15u AS=0.1005p
+ AD=0.0555p PS=1.34u PD=0.74u rfmode=0
M$2838 WBL[12] WWL[11] \$985 GND sg13_hv_nmos L=0.45u W=0.15u AS=0.0555p
+ AD=0.1005p PS=0.74u PD=1.34u rfmode=0
M$2839 \$908 WWL[10] WBL[13] GND sg13_hv_nmos L=0.45u W=0.15u AS=0.1005p
+ AD=0.0555p PS=1.34u PD=0.74u rfmode=0
M$2840 WBL[13] WWL[11] \$986 GND sg13_hv_nmos L=0.45u W=0.15u AS=0.0555p
+ AD=0.1005p PS=0.74u PD=1.34u rfmode=0
M$2841 \$909 WWL[10] WBL[14] GND sg13_hv_nmos L=0.45u W=0.15u AS=0.1005p
+ AD=0.0555p PS=1.34u PD=0.74u rfmode=0
M$2842 WBL[14] WWL[11] \$987 GND sg13_hv_nmos L=0.45u W=0.15u AS=0.0555p
+ AD=0.1005p PS=0.74u PD=1.34u rfmode=0
M$2843 \$910 WWL[10] WBL[15] GND sg13_hv_nmos L=0.45u W=0.15u AS=0.1005p
+ AD=0.0555p PS=1.34u PD=0.74u rfmode=0
M$2844 WBL[15] WWL[11] \$988 GND sg13_hv_nmos L=0.45u W=0.15u AS=0.0555p
+ AD=0.1005p PS=0.74u PD=1.34u rfmode=0
M$2845 \$911 WWL[10] WBL[16] GND sg13_hv_nmos L=0.45u W=0.15u AS=0.1005p
+ AD=0.0555p PS=1.34u PD=0.74u rfmode=0
M$2846 WBL[16] WWL[11] \$989 GND sg13_hv_nmos L=0.45u W=0.15u AS=0.0555p
+ AD=0.1005p PS=0.74u PD=1.34u rfmode=0
M$2847 \$912 WWL[10] WBL[17] GND sg13_hv_nmos L=0.45u W=0.15u AS=0.1005p
+ AD=0.0555p PS=1.34u PD=0.74u rfmode=0
M$2848 WBL[17] WWL[11] \$990 GND sg13_hv_nmos L=0.45u W=0.15u AS=0.0555p
+ AD=0.1005p PS=0.74u PD=1.34u rfmode=0
M$2849 \$913 WWL[10] WBL[18] GND sg13_hv_nmos L=0.45u W=0.15u AS=0.1005p
+ AD=0.0555p PS=1.34u PD=0.74u rfmode=0
M$2850 WBL[18] WWL[11] \$991 GND sg13_hv_nmos L=0.45u W=0.15u AS=0.0555p
+ AD=0.1005p PS=0.74u PD=1.34u rfmode=0
M$2851 \$914 WWL[10] WBL[19] GND sg13_hv_nmos L=0.45u W=0.15u AS=0.1005p
+ AD=0.0555p PS=1.34u PD=0.74u rfmode=0
M$2852 WBL[19] WWL[11] \$992 GND sg13_hv_nmos L=0.45u W=0.15u AS=0.0555p
+ AD=0.1005p PS=0.74u PD=1.34u rfmode=0
M$2853 \$915 WWL[10] WBL[20] GND sg13_hv_nmos L=0.45u W=0.15u AS=0.1005p
+ AD=0.0555p PS=1.34u PD=0.74u rfmode=0
M$2854 WBL[20] WWL[11] \$993 GND sg13_hv_nmos L=0.45u W=0.15u AS=0.0555p
+ AD=0.1005p PS=0.74u PD=1.34u rfmode=0
M$2855 \$916 WWL[10] WBL[21] GND sg13_hv_nmos L=0.45u W=0.15u AS=0.1005p
+ AD=0.0555p PS=1.34u PD=0.74u rfmode=0
M$2856 WBL[21] WWL[11] \$994 GND sg13_hv_nmos L=0.45u W=0.15u AS=0.0555p
+ AD=0.1005p PS=0.74u PD=1.34u rfmode=0
M$2857 \$917 WWL[10] WBL[22] GND sg13_hv_nmos L=0.45u W=0.15u AS=0.1005p
+ AD=0.0555p PS=1.34u PD=0.74u rfmode=0
M$2858 WBL[22] WWL[11] \$995 GND sg13_hv_nmos L=0.45u W=0.15u AS=0.0555p
+ AD=0.1005p PS=0.74u PD=1.34u rfmode=0
M$2859 \$918 WWL[10] WBL[23] GND sg13_hv_nmos L=0.45u W=0.15u AS=0.1005p
+ AD=0.0555p PS=1.34u PD=0.74u rfmode=0
M$2860 WBL[23] WWL[11] \$996 GND sg13_hv_nmos L=0.45u W=0.15u AS=0.0555p
+ AD=0.1005p PS=0.74u PD=1.34u rfmode=0
M$2861 \$919 WWL[10] WBL[24] GND sg13_hv_nmos L=0.45u W=0.15u AS=0.1005p
+ AD=0.0555p PS=1.34u PD=0.74u rfmode=0
M$2862 WBL[24] WWL[11] \$997 GND sg13_hv_nmos L=0.45u W=0.15u AS=0.0555p
+ AD=0.1005p PS=0.74u PD=1.34u rfmode=0
M$2863 \$920 WWL[10] WBL[25] GND sg13_hv_nmos L=0.45u W=0.15u AS=0.1005p
+ AD=0.0555p PS=1.34u PD=0.74u rfmode=0
M$2864 WBL[25] WWL[11] \$998 GND sg13_hv_nmos L=0.45u W=0.15u AS=0.0555p
+ AD=0.1005p PS=0.74u PD=1.34u rfmode=0
M$2865 \$921 WWL[10] WBL[26] GND sg13_hv_nmos L=0.45u W=0.15u AS=0.1005p
+ AD=0.0555p PS=1.34u PD=0.74u rfmode=0
M$2866 WBL[26] WWL[11] \$999 GND sg13_hv_nmos L=0.45u W=0.15u AS=0.0555p
+ AD=0.1005p PS=0.74u PD=1.34u rfmode=0
M$2867 \$922 WWL[10] WBL[27] GND sg13_hv_nmos L=0.45u W=0.15u AS=0.1005p
+ AD=0.0555p PS=1.34u PD=0.74u rfmode=0
M$2868 WBL[27] WWL[11] \$1000 GND sg13_hv_nmos L=0.45u W=0.15u AS=0.0555p
+ AD=0.1005p PS=0.74u PD=1.34u rfmode=0
M$2869 \$923 WWL[10] WBL[28] GND sg13_hv_nmos L=0.45u W=0.15u AS=0.1005p
+ AD=0.0555p PS=1.34u PD=0.74u rfmode=0
M$2870 WBL[28] WWL[11] \$1001 GND sg13_hv_nmos L=0.45u W=0.15u AS=0.0555p
+ AD=0.1005p PS=0.74u PD=1.34u rfmode=0
M$2871 \$924 WWL[10] WBL[29] GND sg13_hv_nmos L=0.45u W=0.15u AS=0.1005p
+ AD=0.0555p PS=1.34u PD=0.74u rfmode=0
M$2872 WBL[29] WWL[11] \$1002 GND sg13_hv_nmos L=0.45u W=0.15u AS=0.0555p
+ AD=0.1005p PS=0.74u PD=1.34u rfmode=0
M$2873 \$925 WWL[10] WBL[30] GND sg13_hv_nmos L=0.45u W=0.15u AS=0.1005p
+ AD=0.0555p PS=1.34u PD=0.74u rfmode=0
M$2874 WBL[30] WWL[11] \$1003 GND sg13_hv_nmos L=0.45u W=0.15u AS=0.0555p
+ AD=0.1005p PS=0.74u PD=1.34u rfmode=0
M$2875 \$926 WWL[10] WBL[31] GND sg13_hv_nmos L=0.45u W=0.15u AS=0.1005p
+ AD=0.0555p PS=1.34u PD=0.74u rfmode=0
M$2876 WBL[31] WWL[11] \$1004 GND sg13_hv_nmos L=0.45u W=0.15u AS=0.0555p
+ AD=0.1005p PS=0.74u PD=1.34u rfmode=0
M$2877 \$927 WWL[10] WBL[32] GND sg13_hv_nmos L=0.45u W=0.15u AS=0.1005p
+ AD=0.0555p PS=1.34u PD=0.74u rfmode=0
M$2878 WBL[32] WWL[11] \$1005 GND sg13_hv_nmos L=0.45u W=0.15u AS=0.0555p
+ AD=0.1005p PS=0.74u PD=1.34u rfmode=0
M$2879 \$928 WWL[10] WBL[33] GND sg13_hv_nmos L=0.45u W=0.15u AS=0.1005p
+ AD=0.0555p PS=1.34u PD=0.74u rfmode=0
M$2880 WBL[33] WWL[11] \$1006 GND sg13_hv_nmos L=0.45u W=0.15u AS=0.0555p
+ AD=0.1005p PS=0.74u PD=1.34u rfmode=0
M$2881 \$929 WWL[10] WBL[34] GND sg13_hv_nmos L=0.45u W=0.15u AS=0.1005p
+ AD=0.0555p PS=1.34u PD=0.74u rfmode=0
M$2882 WBL[34] WWL[11] \$1007 GND sg13_hv_nmos L=0.45u W=0.15u AS=0.0555p
+ AD=0.1005p PS=0.74u PD=1.34u rfmode=0
M$2883 \$930 WWL[10] WBL[35] GND sg13_hv_nmos L=0.45u W=0.15u AS=0.1005p
+ AD=0.0555p PS=1.34u PD=0.74u rfmode=0
M$2884 WBL[35] WWL[11] \$1008 GND sg13_hv_nmos L=0.45u W=0.15u AS=0.0555p
+ AD=0.1005p PS=0.74u PD=1.34u rfmode=0
M$2885 \$931 WWL[10] WBL[36] GND sg13_hv_nmos L=0.45u W=0.15u AS=0.1005p
+ AD=0.0555p PS=1.34u PD=0.74u rfmode=0
M$2886 WBL[36] WWL[11] \$1009 GND sg13_hv_nmos L=0.45u W=0.15u AS=0.0555p
+ AD=0.1005p PS=0.74u PD=1.34u rfmode=0
M$2887 \$932 WWL[10] WBL[37] GND sg13_hv_nmos L=0.45u W=0.15u AS=0.1005p
+ AD=0.0555p PS=1.34u PD=0.74u rfmode=0
M$2888 WBL[37] WWL[11] \$1010 GND sg13_hv_nmos L=0.45u W=0.15u AS=0.0555p
+ AD=0.1005p PS=0.74u PD=1.34u rfmode=0
M$2889 \$1058 WWL[12] WBL[0] GND sg13_hv_nmos L=0.45u W=0.15u AS=0.1005p
+ AD=0.0555p PS=1.34u PD=0.74u rfmode=0
M$2890 WBL[0] WWL[13] \$1136 GND sg13_hv_nmos L=0.45u W=0.15u AS=0.0555p
+ AD=0.1005p PS=0.74u PD=1.34u rfmode=0
M$2891 \$1059 WWL[12] WBL[1] GND sg13_hv_nmos L=0.45u W=0.15u AS=0.1005p
+ AD=0.0555p PS=1.34u PD=0.74u rfmode=0
M$2892 WBL[1] WWL[13] \$1137 GND sg13_hv_nmos L=0.45u W=0.15u AS=0.0555p
+ AD=0.1005p PS=0.74u PD=1.34u rfmode=0
M$2893 \$1060 WWL[12] WBL[2] GND sg13_hv_nmos L=0.45u W=0.15u AS=0.1005p
+ AD=0.0555p PS=1.34u PD=0.74u rfmode=0
M$2894 WBL[2] WWL[13] \$1138 GND sg13_hv_nmos L=0.45u W=0.15u AS=0.0555p
+ AD=0.1005p PS=0.74u PD=1.34u rfmode=0
M$2895 \$1061 WWL[12] WBL[3] GND sg13_hv_nmos L=0.45u W=0.15u AS=0.1005p
+ AD=0.0555p PS=1.34u PD=0.74u rfmode=0
M$2896 WBL[3] WWL[13] \$1139 GND sg13_hv_nmos L=0.45u W=0.15u AS=0.0555p
+ AD=0.1005p PS=0.74u PD=1.34u rfmode=0
M$2897 \$1062 WWL[12] WBL[4] GND sg13_hv_nmos L=0.45u W=0.15u AS=0.1005p
+ AD=0.0555p PS=1.34u PD=0.74u rfmode=0
M$2898 WBL[4] WWL[13] \$1140 GND sg13_hv_nmos L=0.45u W=0.15u AS=0.0555p
+ AD=0.1005p PS=0.74u PD=1.34u rfmode=0
M$2899 \$1063 WWL[12] WBL[5] GND sg13_hv_nmos L=0.45u W=0.15u AS=0.1005p
+ AD=0.0555p PS=1.34u PD=0.74u rfmode=0
M$2900 WBL[5] WWL[13] \$1141 GND sg13_hv_nmos L=0.45u W=0.15u AS=0.0555p
+ AD=0.1005p PS=0.74u PD=1.34u rfmode=0
M$2901 \$1064 WWL[12] WBL[6] GND sg13_hv_nmos L=0.45u W=0.15u AS=0.1005p
+ AD=0.0555p PS=1.34u PD=0.74u rfmode=0
M$2902 WBL[6] WWL[13] \$1142 GND sg13_hv_nmos L=0.45u W=0.15u AS=0.0555p
+ AD=0.1005p PS=0.74u PD=1.34u rfmode=0
M$2903 \$1065 WWL[12] WBL[7] GND sg13_hv_nmos L=0.45u W=0.15u AS=0.1005p
+ AD=0.0555p PS=1.34u PD=0.74u rfmode=0
M$2904 WBL[7] WWL[13] \$1143 GND sg13_hv_nmos L=0.45u W=0.15u AS=0.0555p
+ AD=0.1005p PS=0.74u PD=1.34u rfmode=0
M$2905 \$1066 WWL[12] WBL[8] GND sg13_hv_nmos L=0.45u W=0.15u AS=0.1005p
+ AD=0.0555p PS=1.34u PD=0.74u rfmode=0
M$2906 WBL[8] WWL[13] \$1144 GND sg13_hv_nmos L=0.45u W=0.15u AS=0.0555p
+ AD=0.1005p PS=0.74u PD=1.34u rfmode=0
M$2907 \$1067 WWL[12] WBL[9] GND sg13_hv_nmos L=0.45u W=0.15u AS=0.1005p
+ AD=0.0555p PS=1.34u PD=0.74u rfmode=0
M$2908 WBL[9] WWL[13] \$1145 GND sg13_hv_nmos L=0.45u W=0.15u AS=0.0555p
+ AD=0.1005p PS=0.74u PD=1.34u rfmode=0
M$2909 \$1068 WWL[12] WBL[10] GND sg13_hv_nmos L=0.45u W=0.15u AS=0.1005p
+ AD=0.0555p PS=1.34u PD=0.74u rfmode=0
M$2910 WBL[10] WWL[13] \$1146 GND sg13_hv_nmos L=0.45u W=0.15u AS=0.0555p
+ AD=0.1005p PS=0.74u PD=1.34u rfmode=0
M$2911 \$1069 WWL[12] WBL[11] GND sg13_hv_nmos L=0.45u W=0.15u AS=0.1005p
+ AD=0.0555p PS=1.34u PD=0.74u rfmode=0
M$2912 WBL[11] WWL[13] \$1147 GND sg13_hv_nmos L=0.45u W=0.15u AS=0.0555p
+ AD=0.1005p PS=0.74u PD=1.34u rfmode=0
M$2913 \$1070 WWL[12] WBL[12] GND sg13_hv_nmos L=0.45u W=0.15u AS=0.1005p
+ AD=0.0555p PS=1.34u PD=0.74u rfmode=0
M$2914 WBL[12] WWL[13] \$1148 GND sg13_hv_nmos L=0.45u W=0.15u AS=0.0555p
+ AD=0.1005p PS=0.74u PD=1.34u rfmode=0
M$2915 \$1071 WWL[12] WBL[13] GND sg13_hv_nmos L=0.45u W=0.15u AS=0.1005p
+ AD=0.0555p PS=1.34u PD=0.74u rfmode=0
M$2916 WBL[13] WWL[13] \$1149 GND sg13_hv_nmos L=0.45u W=0.15u AS=0.0555p
+ AD=0.1005p PS=0.74u PD=1.34u rfmode=0
M$2917 \$1072 WWL[12] WBL[14] GND sg13_hv_nmos L=0.45u W=0.15u AS=0.1005p
+ AD=0.0555p PS=1.34u PD=0.74u rfmode=0
M$2918 WBL[14] WWL[13] \$1150 GND sg13_hv_nmos L=0.45u W=0.15u AS=0.0555p
+ AD=0.1005p PS=0.74u PD=1.34u rfmode=0
M$2919 \$1073 WWL[12] WBL[15] GND sg13_hv_nmos L=0.45u W=0.15u AS=0.1005p
+ AD=0.0555p PS=1.34u PD=0.74u rfmode=0
M$2920 WBL[15] WWL[13] \$1151 GND sg13_hv_nmos L=0.45u W=0.15u AS=0.0555p
+ AD=0.1005p PS=0.74u PD=1.34u rfmode=0
M$2921 \$1074 WWL[12] WBL[16] GND sg13_hv_nmos L=0.45u W=0.15u AS=0.1005p
+ AD=0.0555p PS=1.34u PD=0.74u rfmode=0
M$2922 WBL[16] WWL[13] \$1152 GND sg13_hv_nmos L=0.45u W=0.15u AS=0.0555p
+ AD=0.1005p PS=0.74u PD=1.34u rfmode=0
M$2923 \$1075 WWL[12] WBL[17] GND sg13_hv_nmos L=0.45u W=0.15u AS=0.1005p
+ AD=0.0555p PS=1.34u PD=0.74u rfmode=0
M$2924 WBL[17] WWL[13] \$1153 GND sg13_hv_nmos L=0.45u W=0.15u AS=0.0555p
+ AD=0.1005p PS=0.74u PD=1.34u rfmode=0
M$2925 \$1076 WWL[12] WBL[18] GND sg13_hv_nmos L=0.45u W=0.15u AS=0.1005p
+ AD=0.0555p PS=1.34u PD=0.74u rfmode=0
M$2926 WBL[18] WWL[13] \$1154 GND sg13_hv_nmos L=0.45u W=0.15u AS=0.0555p
+ AD=0.1005p PS=0.74u PD=1.34u rfmode=0
M$2927 \$1077 WWL[12] WBL[19] GND sg13_hv_nmos L=0.45u W=0.15u AS=0.1005p
+ AD=0.0555p PS=1.34u PD=0.74u rfmode=0
M$2928 WBL[19] WWL[13] \$1155 GND sg13_hv_nmos L=0.45u W=0.15u AS=0.0555p
+ AD=0.1005p PS=0.74u PD=1.34u rfmode=0
M$2929 \$1078 WWL[12] WBL[20] GND sg13_hv_nmos L=0.45u W=0.15u AS=0.1005p
+ AD=0.0555p PS=1.34u PD=0.74u rfmode=0
M$2930 WBL[20] WWL[13] \$1156 GND sg13_hv_nmos L=0.45u W=0.15u AS=0.0555p
+ AD=0.1005p PS=0.74u PD=1.34u rfmode=0
M$2931 \$1079 WWL[12] WBL[21] GND sg13_hv_nmos L=0.45u W=0.15u AS=0.1005p
+ AD=0.0555p PS=1.34u PD=0.74u rfmode=0
M$2932 WBL[21] WWL[13] \$1157 GND sg13_hv_nmos L=0.45u W=0.15u AS=0.0555p
+ AD=0.1005p PS=0.74u PD=1.34u rfmode=0
M$2933 \$1080 WWL[12] WBL[22] GND sg13_hv_nmos L=0.45u W=0.15u AS=0.1005p
+ AD=0.0555p PS=1.34u PD=0.74u rfmode=0
M$2934 WBL[22] WWL[13] \$1158 GND sg13_hv_nmos L=0.45u W=0.15u AS=0.0555p
+ AD=0.1005p PS=0.74u PD=1.34u rfmode=0
M$2935 \$1081 WWL[12] WBL[23] GND sg13_hv_nmos L=0.45u W=0.15u AS=0.1005p
+ AD=0.0555p PS=1.34u PD=0.74u rfmode=0
M$2936 WBL[23] WWL[13] \$1159 GND sg13_hv_nmos L=0.45u W=0.15u AS=0.0555p
+ AD=0.1005p PS=0.74u PD=1.34u rfmode=0
M$2937 \$1082 WWL[12] WBL[24] GND sg13_hv_nmos L=0.45u W=0.15u AS=0.1005p
+ AD=0.0555p PS=1.34u PD=0.74u rfmode=0
M$2938 WBL[24] WWL[13] \$1160 GND sg13_hv_nmos L=0.45u W=0.15u AS=0.0555p
+ AD=0.1005p PS=0.74u PD=1.34u rfmode=0
M$2939 \$1083 WWL[12] WBL[25] GND sg13_hv_nmos L=0.45u W=0.15u AS=0.1005p
+ AD=0.0555p PS=1.34u PD=0.74u rfmode=0
M$2940 WBL[25] WWL[13] \$1161 GND sg13_hv_nmos L=0.45u W=0.15u AS=0.0555p
+ AD=0.1005p PS=0.74u PD=1.34u rfmode=0
M$2941 \$1084 WWL[12] WBL[26] GND sg13_hv_nmos L=0.45u W=0.15u AS=0.1005p
+ AD=0.0555p PS=1.34u PD=0.74u rfmode=0
M$2942 WBL[26] WWL[13] \$1162 GND sg13_hv_nmos L=0.45u W=0.15u AS=0.0555p
+ AD=0.1005p PS=0.74u PD=1.34u rfmode=0
M$2943 \$1085 WWL[12] WBL[27] GND sg13_hv_nmos L=0.45u W=0.15u AS=0.1005p
+ AD=0.0555p PS=1.34u PD=0.74u rfmode=0
M$2944 WBL[27] WWL[13] \$1163 GND sg13_hv_nmos L=0.45u W=0.15u AS=0.0555p
+ AD=0.1005p PS=0.74u PD=1.34u rfmode=0
M$2945 \$1086 WWL[12] WBL[28] GND sg13_hv_nmos L=0.45u W=0.15u AS=0.1005p
+ AD=0.0555p PS=1.34u PD=0.74u rfmode=0
M$2946 WBL[28] WWL[13] \$1164 GND sg13_hv_nmos L=0.45u W=0.15u AS=0.0555p
+ AD=0.1005p PS=0.74u PD=1.34u rfmode=0
M$2947 \$1087 WWL[12] WBL[29] GND sg13_hv_nmos L=0.45u W=0.15u AS=0.1005p
+ AD=0.0555p PS=1.34u PD=0.74u rfmode=0
M$2948 WBL[29] WWL[13] \$1165 GND sg13_hv_nmos L=0.45u W=0.15u AS=0.0555p
+ AD=0.1005p PS=0.74u PD=1.34u rfmode=0
M$2949 \$1088 WWL[12] WBL[30] GND sg13_hv_nmos L=0.45u W=0.15u AS=0.1005p
+ AD=0.0555p PS=1.34u PD=0.74u rfmode=0
M$2950 WBL[30] WWL[13] \$1166 GND sg13_hv_nmos L=0.45u W=0.15u AS=0.0555p
+ AD=0.1005p PS=0.74u PD=1.34u rfmode=0
M$2951 \$1089 WWL[12] WBL[31] GND sg13_hv_nmos L=0.45u W=0.15u AS=0.1005p
+ AD=0.0555p PS=1.34u PD=0.74u rfmode=0
M$2952 WBL[31] WWL[13] \$1167 GND sg13_hv_nmos L=0.45u W=0.15u AS=0.0555p
+ AD=0.1005p PS=0.74u PD=1.34u rfmode=0
M$2953 \$1090 WWL[12] WBL[32] GND sg13_hv_nmos L=0.45u W=0.15u AS=0.1005p
+ AD=0.0555p PS=1.34u PD=0.74u rfmode=0
M$2954 WBL[32] WWL[13] \$1168 GND sg13_hv_nmos L=0.45u W=0.15u AS=0.0555p
+ AD=0.1005p PS=0.74u PD=1.34u rfmode=0
M$2955 \$1091 WWL[12] WBL[33] GND sg13_hv_nmos L=0.45u W=0.15u AS=0.1005p
+ AD=0.0555p PS=1.34u PD=0.74u rfmode=0
M$2956 WBL[33] WWL[13] \$1169 GND sg13_hv_nmos L=0.45u W=0.15u AS=0.0555p
+ AD=0.1005p PS=0.74u PD=1.34u rfmode=0
M$2957 \$1092 WWL[12] WBL[34] GND sg13_hv_nmos L=0.45u W=0.15u AS=0.1005p
+ AD=0.0555p PS=1.34u PD=0.74u rfmode=0
M$2958 WBL[34] WWL[13] \$1170 GND sg13_hv_nmos L=0.45u W=0.15u AS=0.0555p
+ AD=0.1005p PS=0.74u PD=1.34u rfmode=0
M$2959 \$1093 WWL[12] WBL[35] GND sg13_hv_nmos L=0.45u W=0.15u AS=0.1005p
+ AD=0.0555p PS=1.34u PD=0.74u rfmode=0
M$2960 WBL[35] WWL[13] \$1171 GND sg13_hv_nmos L=0.45u W=0.15u AS=0.0555p
+ AD=0.1005p PS=0.74u PD=1.34u rfmode=0
M$2961 \$1094 WWL[12] WBL[36] GND sg13_hv_nmos L=0.45u W=0.15u AS=0.1005p
+ AD=0.0555p PS=1.34u PD=0.74u rfmode=0
M$2962 WBL[36] WWL[13] \$1172 GND sg13_hv_nmos L=0.45u W=0.15u AS=0.0555p
+ AD=0.1005p PS=0.74u PD=1.34u rfmode=0
M$2963 \$1095 WWL[12] WBL[37] GND sg13_hv_nmos L=0.45u W=0.15u AS=0.1005p
+ AD=0.0555p PS=1.34u PD=0.74u rfmode=0
M$2964 WBL[37] WWL[13] \$1173 GND sg13_hv_nmos L=0.45u W=0.15u AS=0.0555p
+ AD=0.1005p PS=0.74u PD=1.34u rfmode=0
M$2965 \$1221 WWL[14] WBL[0] GND sg13_hv_nmos L=0.45u W=0.15u AS=0.1005p
+ AD=0.0555p PS=1.34u PD=0.74u rfmode=0
M$2966 WBL[0] WWL[15] \$1299 GND sg13_hv_nmos L=0.45u W=0.15u AS=0.0555p
+ AD=0.1005p PS=0.74u PD=1.34u rfmode=0
M$2967 \$1222 WWL[14] WBL[1] GND sg13_hv_nmos L=0.45u W=0.15u AS=0.1005p
+ AD=0.0555p PS=1.34u PD=0.74u rfmode=0
M$2968 WBL[1] WWL[15] \$1300 GND sg13_hv_nmos L=0.45u W=0.15u AS=0.0555p
+ AD=0.1005p PS=0.74u PD=1.34u rfmode=0
M$2969 \$1223 WWL[14] WBL[2] GND sg13_hv_nmos L=0.45u W=0.15u AS=0.1005p
+ AD=0.0555p PS=1.34u PD=0.74u rfmode=0
M$2970 WBL[2] WWL[15] \$1301 GND sg13_hv_nmos L=0.45u W=0.15u AS=0.0555p
+ AD=0.1005p PS=0.74u PD=1.34u rfmode=0
M$2971 \$1224 WWL[14] WBL[3] GND sg13_hv_nmos L=0.45u W=0.15u AS=0.1005p
+ AD=0.0555p PS=1.34u PD=0.74u rfmode=0
M$2972 WBL[3] WWL[15] \$1302 GND sg13_hv_nmos L=0.45u W=0.15u AS=0.0555p
+ AD=0.1005p PS=0.74u PD=1.34u rfmode=0
M$2973 \$1225 WWL[14] WBL[4] GND sg13_hv_nmos L=0.45u W=0.15u AS=0.1005p
+ AD=0.0555p PS=1.34u PD=0.74u rfmode=0
M$2974 WBL[4] WWL[15] \$1303 GND sg13_hv_nmos L=0.45u W=0.15u AS=0.0555p
+ AD=0.1005p PS=0.74u PD=1.34u rfmode=0
M$2975 \$1226 WWL[14] WBL[5] GND sg13_hv_nmos L=0.45u W=0.15u AS=0.1005p
+ AD=0.0555p PS=1.34u PD=0.74u rfmode=0
M$2976 WBL[5] WWL[15] \$1304 GND sg13_hv_nmos L=0.45u W=0.15u AS=0.0555p
+ AD=0.1005p PS=0.74u PD=1.34u rfmode=0
M$2977 \$1227 WWL[14] WBL[6] GND sg13_hv_nmos L=0.45u W=0.15u AS=0.1005p
+ AD=0.0555p PS=1.34u PD=0.74u rfmode=0
M$2978 WBL[6] WWL[15] \$1305 GND sg13_hv_nmos L=0.45u W=0.15u AS=0.0555p
+ AD=0.1005p PS=0.74u PD=1.34u rfmode=0
M$2979 \$1228 WWL[14] WBL[7] GND sg13_hv_nmos L=0.45u W=0.15u AS=0.1005p
+ AD=0.0555p PS=1.34u PD=0.74u rfmode=0
M$2980 WBL[7] WWL[15] \$1306 GND sg13_hv_nmos L=0.45u W=0.15u AS=0.0555p
+ AD=0.1005p PS=0.74u PD=1.34u rfmode=0
M$2981 \$1229 WWL[14] WBL[8] GND sg13_hv_nmos L=0.45u W=0.15u AS=0.1005p
+ AD=0.0555p PS=1.34u PD=0.74u rfmode=0
M$2982 WBL[8] WWL[15] \$1307 GND sg13_hv_nmos L=0.45u W=0.15u AS=0.0555p
+ AD=0.1005p PS=0.74u PD=1.34u rfmode=0
M$2983 \$1230 WWL[14] WBL[9] GND sg13_hv_nmos L=0.45u W=0.15u AS=0.1005p
+ AD=0.0555p PS=1.34u PD=0.74u rfmode=0
M$2984 WBL[9] WWL[15] \$1308 GND sg13_hv_nmos L=0.45u W=0.15u AS=0.0555p
+ AD=0.1005p PS=0.74u PD=1.34u rfmode=0
M$2985 \$1231 WWL[14] WBL[10] GND sg13_hv_nmos L=0.45u W=0.15u AS=0.1005p
+ AD=0.0555p PS=1.34u PD=0.74u rfmode=0
M$2986 WBL[10] WWL[15] \$1309 GND sg13_hv_nmos L=0.45u W=0.15u AS=0.0555p
+ AD=0.1005p PS=0.74u PD=1.34u rfmode=0
M$2987 \$1232 WWL[14] WBL[11] GND sg13_hv_nmos L=0.45u W=0.15u AS=0.1005p
+ AD=0.0555p PS=1.34u PD=0.74u rfmode=0
M$2988 WBL[11] WWL[15] \$1310 GND sg13_hv_nmos L=0.45u W=0.15u AS=0.0555p
+ AD=0.1005p PS=0.74u PD=1.34u rfmode=0
M$2989 \$1233 WWL[14] WBL[12] GND sg13_hv_nmos L=0.45u W=0.15u AS=0.1005p
+ AD=0.0555p PS=1.34u PD=0.74u rfmode=0
M$2990 WBL[12] WWL[15] \$1311 GND sg13_hv_nmos L=0.45u W=0.15u AS=0.0555p
+ AD=0.1005p PS=0.74u PD=1.34u rfmode=0
M$2991 \$1234 WWL[14] WBL[13] GND sg13_hv_nmos L=0.45u W=0.15u AS=0.1005p
+ AD=0.0555p PS=1.34u PD=0.74u rfmode=0
M$2992 WBL[13] WWL[15] \$1312 GND sg13_hv_nmos L=0.45u W=0.15u AS=0.0555p
+ AD=0.1005p PS=0.74u PD=1.34u rfmode=0
M$2993 \$1235 WWL[14] WBL[14] GND sg13_hv_nmos L=0.45u W=0.15u AS=0.1005p
+ AD=0.0555p PS=1.34u PD=0.74u rfmode=0
M$2994 WBL[14] WWL[15] \$1313 GND sg13_hv_nmos L=0.45u W=0.15u AS=0.0555p
+ AD=0.1005p PS=0.74u PD=1.34u rfmode=0
M$2995 \$1236 WWL[14] WBL[15] GND sg13_hv_nmos L=0.45u W=0.15u AS=0.1005p
+ AD=0.0555p PS=1.34u PD=0.74u rfmode=0
M$2996 WBL[15] WWL[15] \$1314 GND sg13_hv_nmos L=0.45u W=0.15u AS=0.0555p
+ AD=0.1005p PS=0.74u PD=1.34u rfmode=0
M$2997 \$1237 WWL[14] WBL[16] GND sg13_hv_nmos L=0.45u W=0.15u AS=0.1005p
+ AD=0.0555p PS=1.34u PD=0.74u rfmode=0
M$2998 WBL[16] WWL[15] \$1315 GND sg13_hv_nmos L=0.45u W=0.15u AS=0.0555p
+ AD=0.1005p PS=0.74u PD=1.34u rfmode=0
M$2999 \$1238 WWL[14] WBL[17] GND sg13_hv_nmos L=0.45u W=0.15u AS=0.1005p
+ AD=0.0555p PS=1.34u PD=0.74u rfmode=0
M$3000 WBL[17] WWL[15] \$1316 GND sg13_hv_nmos L=0.45u W=0.15u AS=0.0555p
+ AD=0.1005p PS=0.74u PD=1.34u rfmode=0
M$3001 \$1239 WWL[14] WBL[18] GND sg13_hv_nmos L=0.45u W=0.15u AS=0.1005p
+ AD=0.0555p PS=1.34u PD=0.74u rfmode=0
M$3002 WBL[18] WWL[15] \$1317 GND sg13_hv_nmos L=0.45u W=0.15u AS=0.0555p
+ AD=0.1005p PS=0.74u PD=1.34u rfmode=0
M$3003 \$1240 WWL[14] WBL[19] GND sg13_hv_nmos L=0.45u W=0.15u AS=0.1005p
+ AD=0.0555p PS=1.34u PD=0.74u rfmode=0
M$3004 WBL[19] WWL[15] \$1318 GND sg13_hv_nmos L=0.45u W=0.15u AS=0.0555p
+ AD=0.1005p PS=0.74u PD=1.34u rfmode=0
M$3005 \$1241 WWL[14] WBL[20] GND sg13_hv_nmos L=0.45u W=0.15u AS=0.1005p
+ AD=0.0555p PS=1.34u PD=0.74u rfmode=0
M$3006 WBL[20] WWL[15] \$1319 GND sg13_hv_nmos L=0.45u W=0.15u AS=0.0555p
+ AD=0.1005p PS=0.74u PD=1.34u rfmode=0
M$3007 \$1242 WWL[14] WBL[21] GND sg13_hv_nmos L=0.45u W=0.15u AS=0.1005p
+ AD=0.0555p PS=1.34u PD=0.74u rfmode=0
M$3008 WBL[21] WWL[15] \$1320 GND sg13_hv_nmos L=0.45u W=0.15u AS=0.0555p
+ AD=0.1005p PS=0.74u PD=1.34u rfmode=0
M$3009 \$1243 WWL[14] WBL[22] GND sg13_hv_nmos L=0.45u W=0.15u AS=0.1005p
+ AD=0.0555p PS=1.34u PD=0.74u rfmode=0
M$3010 WBL[22] WWL[15] \$1321 GND sg13_hv_nmos L=0.45u W=0.15u AS=0.0555p
+ AD=0.1005p PS=0.74u PD=1.34u rfmode=0
M$3011 \$1244 WWL[14] WBL[23] GND sg13_hv_nmos L=0.45u W=0.15u AS=0.1005p
+ AD=0.0555p PS=1.34u PD=0.74u rfmode=0
M$3012 WBL[23] WWL[15] \$1322 GND sg13_hv_nmos L=0.45u W=0.15u AS=0.0555p
+ AD=0.1005p PS=0.74u PD=1.34u rfmode=0
M$3013 \$1245 WWL[14] WBL[24] GND sg13_hv_nmos L=0.45u W=0.15u AS=0.1005p
+ AD=0.0555p PS=1.34u PD=0.74u rfmode=0
M$3014 WBL[24] WWL[15] \$1323 GND sg13_hv_nmos L=0.45u W=0.15u AS=0.0555p
+ AD=0.1005p PS=0.74u PD=1.34u rfmode=0
M$3015 \$1246 WWL[14] WBL[25] GND sg13_hv_nmos L=0.45u W=0.15u AS=0.1005p
+ AD=0.0555p PS=1.34u PD=0.74u rfmode=0
M$3016 WBL[25] WWL[15] \$1324 GND sg13_hv_nmos L=0.45u W=0.15u AS=0.0555p
+ AD=0.1005p PS=0.74u PD=1.34u rfmode=0
M$3017 \$1247 WWL[14] WBL[26] GND sg13_hv_nmos L=0.45u W=0.15u AS=0.1005p
+ AD=0.0555p PS=1.34u PD=0.74u rfmode=0
M$3018 WBL[26] WWL[15] \$1325 GND sg13_hv_nmos L=0.45u W=0.15u AS=0.0555p
+ AD=0.1005p PS=0.74u PD=1.34u rfmode=0
M$3019 \$1248 WWL[14] WBL[27] GND sg13_hv_nmos L=0.45u W=0.15u AS=0.1005p
+ AD=0.0555p PS=1.34u PD=0.74u rfmode=0
M$3020 WBL[27] WWL[15] \$1326 GND sg13_hv_nmos L=0.45u W=0.15u AS=0.0555p
+ AD=0.1005p PS=0.74u PD=1.34u rfmode=0
M$3021 \$1249 WWL[14] WBL[28] GND sg13_hv_nmos L=0.45u W=0.15u AS=0.1005p
+ AD=0.0555p PS=1.34u PD=0.74u rfmode=0
M$3022 WBL[28] WWL[15] \$1327 GND sg13_hv_nmos L=0.45u W=0.15u AS=0.0555p
+ AD=0.1005p PS=0.74u PD=1.34u rfmode=0
M$3023 \$1250 WWL[14] WBL[29] GND sg13_hv_nmos L=0.45u W=0.15u AS=0.1005p
+ AD=0.0555p PS=1.34u PD=0.74u rfmode=0
M$3024 WBL[29] WWL[15] \$1328 GND sg13_hv_nmos L=0.45u W=0.15u AS=0.0555p
+ AD=0.1005p PS=0.74u PD=1.34u rfmode=0
M$3025 \$1251 WWL[14] WBL[30] GND sg13_hv_nmos L=0.45u W=0.15u AS=0.1005p
+ AD=0.0555p PS=1.34u PD=0.74u rfmode=0
M$3026 WBL[30] WWL[15] \$1329 GND sg13_hv_nmos L=0.45u W=0.15u AS=0.0555p
+ AD=0.1005p PS=0.74u PD=1.34u rfmode=0
M$3027 \$1252 WWL[14] WBL[31] GND sg13_hv_nmos L=0.45u W=0.15u AS=0.1005p
+ AD=0.0555p PS=1.34u PD=0.74u rfmode=0
M$3028 WBL[31] WWL[15] \$1330 GND sg13_hv_nmos L=0.45u W=0.15u AS=0.0555p
+ AD=0.1005p PS=0.74u PD=1.34u rfmode=0
M$3029 \$1253 WWL[14] WBL[32] GND sg13_hv_nmos L=0.45u W=0.15u AS=0.1005p
+ AD=0.0555p PS=1.34u PD=0.74u rfmode=0
M$3030 WBL[32] WWL[15] \$1331 GND sg13_hv_nmos L=0.45u W=0.15u AS=0.0555p
+ AD=0.1005p PS=0.74u PD=1.34u rfmode=0
M$3031 \$1254 WWL[14] WBL[33] GND sg13_hv_nmos L=0.45u W=0.15u AS=0.1005p
+ AD=0.0555p PS=1.34u PD=0.74u rfmode=0
M$3032 WBL[33] WWL[15] \$1332 GND sg13_hv_nmos L=0.45u W=0.15u AS=0.0555p
+ AD=0.1005p PS=0.74u PD=1.34u rfmode=0
M$3033 \$1255 WWL[14] WBL[34] GND sg13_hv_nmos L=0.45u W=0.15u AS=0.1005p
+ AD=0.0555p PS=1.34u PD=0.74u rfmode=0
M$3034 WBL[34] WWL[15] \$1333 GND sg13_hv_nmos L=0.45u W=0.15u AS=0.0555p
+ AD=0.1005p PS=0.74u PD=1.34u rfmode=0
M$3035 \$1256 WWL[14] WBL[35] GND sg13_hv_nmos L=0.45u W=0.15u AS=0.1005p
+ AD=0.0555p PS=1.34u PD=0.74u rfmode=0
M$3036 WBL[35] WWL[15] \$1334 GND sg13_hv_nmos L=0.45u W=0.15u AS=0.0555p
+ AD=0.1005p PS=0.74u PD=1.34u rfmode=0
M$3037 \$1257 WWL[14] WBL[36] GND sg13_hv_nmos L=0.45u W=0.15u AS=0.1005p
+ AD=0.0555p PS=1.34u PD=0.74u rfmode=0
M$3038 WBL[36] WWL[15] \$1335 GND sg13_hv_nmos L=0.45u W=0.15u AS=0.0555p
+ AD=0.1005p PS=0.74u PD=1.34u rfmode=0
M$3039 \$1258 WWL[14] WBL[37] GND sg13_hv_nmos L=0.45u W=0.15u AS=0.1005p
+ AD=0.0555p PS=1.34u PD=0.74u rfmode=0
M$3040 WBL[37] WWL[15] \$1336 GND sg13_hv_nmos L=0.45u W=0.15u AS=0.0555p
+ AD=0.1005p PS=0.74u PD=1.34u rfmode=0
M$3041 \$1384 WWL[16] WBL[0] GND sg13_hv_nmos L=0.45u W=0.15u AS=0.1005p
+ AD=0.0555p PS=1.34u PD=0.74u rfmode=0
M$3042 WBL[0] WWL[17] \$1462 GND sg13_hv_nmos L=0.45u W=0.15u AS=0.0555p
+ AD=0.1005p PS=0.74u PD=1.34u rfmode=0
M$3043 \$1385 WWL[16] WBL[1] GND sg13_hv_nmos L=0.45u W=0.15u AS=0.1005p
+ AD=0.0555p PS=1.34u PD=0.74u rfmode=0
M$3044 WBL[1] WWL[17] \$1463 GND sg13_hv_nmos L=0.45u W=0.15u AS=0.0555p
+ AD=0.1005p PS=0.74u PD=1.34u rfmode=0
M$3045 \$1386 WWL[16] WBL[2] GND sg13_hv_nmos L=0.45u W=0.15u AS=0.1005p
+ AD=0.0555p PS=1.34u PD=0.74u rfmode=0
M$3046 WBL[2] WWL[17] \$1464 GND sg13_hv_nmos L=0.45u W=0.15u AS=0.0555p
+ AD=0.1005p PS=0.74u PD=1.34u rfmode=0
M$3047 \$1387 WWL[16] WBL[3] GND sg13_hv_nmos L=0.45u W=0.15u AS=0.1005p
+ AD=0.0555p PS=1.34u PD=0.74u rfmode=0
M$3048 WBL[3] WWL[17] \$1465 GND sg13_hv_nmos L=0.45u W=0.15u AS=0.0555p
+ AD=0.1005p PS=0.74u PD=1.34u rfmode=0
M$3049 \$1388 WWL[16] WBL[4] GND sg13_hv_nmos L=0.45u W=0.15u AS=0.1005p
+ AD=0.0555p PS=1.34u PD=0.74u rfmode=0
M$3050 WBL[4] WWL[17] \$1466 GND sg13_hv_nmos L=0.45u W=0.15u AS=0.0555p
+ AD=0.1005p PS=0.74u PD=1.34u rfmode=0
M$3051 \$1389 WWL[16] WBL[5] GND sg13_hv_nmos L=0.45u W=0.15u AS=0.1005p
+ AD=0.0555p PS=1.34u PD=0.74u rfmode=0
M$3052 WBL[5] WWL[17] \$1467 GND sg13_hv_nmos L=0.45u W=0.15u AS=0.0555p
+ AD=0.1005p PS=0.74u PD=1.34u rfmode=0
M$3053 \$1390 WWL[16] WBL[6] GND sg13_hv_nmos L=0.45u W=0.15u AS=0.1005p
+ AD=0.0555p PS=1.34u PD=0.74u rfmode=0
M$3054 WBL[6] WWL[17] \$1468 GND sg13_hv_nmos L=0.45u W=0.15u AS=0.0555p
+ AD=0.1005p PS=0.74u PD=1.34u rfmode=0
M$3055 \$1391 WWL[16] WBL[7] GND sg13_hv_nmos L=0.45u W=0.15u AS=0.1005p
+ AD=0.0555p PS=1.34u PD=0.74u rfmode=0
M$3056 WBL[7] WWL[17] \$1469 GND sg13_hv_nmos L=0.45u W=0.15u AS=0.0555p
+ AD=0.1005p PS=0.74u PD=1.34u rfmode=0
M$3057 \$1392 WWL[16] WBL[8] GND sg13_hv_nmos L=0.45u W=0.15u AS=0.1005p
+ AD=0.0555p PS=1.34u PD=0.74u rfmode=0
M$3058 WBL[8] WWL[17] \$1470 GND sg13_hv_nmos L=0.45u W=0.15u AS=0.0555p
+ AD=0.1005p PS=0.74u PD=1.34u rfmode=0
M$3059 \$1393 WWL[16] WBL[9] GND sg13_hv_nmos L=0.45u W=0.15u AS=0.1005p
+ AD=0.0555p PS=1.34u PD=0.74u rfmode=0
M$3060 WBL[9] WWL[17] \$1471 GND sg13_hv_nmos L=0.45u W=0.15u AS=0.0555p
+ AD=0.1005p PS=0.74u PD=1.34u rfmode=0
M$3061 \$1394 WWL[16] WBL[10] GND sg13_hv_nmos L=0.45u W=0.15u AS=0.1005p
+ AD=0.0555p PS=1.34u PD=0.74u rfmode=0
M$3062 WBL[10] WWL[17] \$1472 GND sg13_hv_nmos L=0.45u W=0.15u AS=0.0555p
+ AD=0.1005p PS=0.74u PD=1.34u rfmode=0
M$3063 \$1395 WWL[16] WBL[11] GND sg13_hv_nmos L=0.45u W=0.15u AS=0.1005p
+ AD=0.0555p PS=1.34u PD=0.74u rfmode=0
M$3064 WBL[11] WWL[17] \$1473 GND sg13_hv_nmos L=0.45u W=0.15u AS=0.0555p
+ AD=0.1005p PS=0.74u PD=1.34u rfmode=0
M$3065 \$1396 WWL[16] WBL[12] GND sg13_hv_nmos L=0.45u W=0.15u AS=0.1005p
+ AD=0.0555p PS=1.34u PD=0.74u rfmode=0
M$3066 WBL[12] WWL[17] \$1474 GND sg13_hv_nmos L=0.45u W=0.15u AS=0.0555p
+ AD=0.1005p PS=0.74u PD=1.34u rfmode=0
M$3067 \$1397 WWL[16] WBL[13] GND sg13_hv_nmos L=0.45u W=0.15u AS=0.1005p
+ AD=0.0555p PS=1.34u PD=0.74u rfmode=0
M$3068 WBL[13] WWL[17] \$1475 GND sg13_hv_nmos L=0.45u W=0.15u AS=0.0555p
+ AD=0.1005p PS=0.74u PD=1.34u rfmode=0
M$3069 \$1398 WWL[16] WBL[14] GND sg13_hv_nmos L=0.45u W=0.15u AS=0.1005p
+ AD=0.0555p PS=1.34u PD=0.74u rfmode=0
M$3070 WBL[14] WWL[17] \$1476 GND sg13_hv_nmos L=0.45u W=0.15u AS=0.0555p
+ AD=0.1005p PS=0.74u PD=1.34u rfmode=0
M$3071 \$1399 WWL[16] WBL[15] GND sg13_hv_nmos L=0.45u W=0.15u AS=0.1005p
+ AD=0.0555p PS=1.34u PD=0.74u rfmode=0
M$3072 WBL[15] WWL[17] \$1477 GND sg13_hv_nmos L=0.45u W=0.15u AS=0.0555p
+ AD=0.1005p PS=0.74u PD=1.34u rfmode=0
M$3073 \$1400 WWL[16] WBL[16] GND sg13_hv_nmos L=0.45u W=0.15u AS=0.1005p
+ AD=0.0555p PS=1.34u PD=0.74u rfmode=0
M$3074 WBL[16] WWL[17] \$1478 GND sg13_hv_nmos L=0.45u W=0.15u AS=0.0555p
+ AD=0.1005p PS=0.74u PD=1.34u rfmode=0
M$3075 \$1401 WWL[16] WBL[17] GND sg13_hv_nmos L=0.45u W=0.15u AS=0.1005p
+ AD=0.0555p PS=1.34u PD=0.74u rfmode=0
M$3076 WBL[17] WWL[17] \$1479 GND sg13_hv_nmos L=0.45u W=0.15u AS=0.0555p
+ AD=0.1005p PS=0.74u PD=1.34u rfmode=0
M$3077 \$1402 WWL[16] WBL[18] GND sg13_hv_nmos L=0.45u W=0.15u AS=0.1005p
+ AD=0.0555p PS=1.34u PD=0.74u rfmode=0
M$3078 WBL[18] WWL[17] \$1480 GND sg13_hv_nmos L=0.45u W=0.15u AS=0.0555p
+ AD=0.1005p PS=0.74u PD=1.34u rfmode=0
M$3079 \$1403 WWL[16] WBL[19] GND sg13_hv_nmos L=0.45u W=0.15u AS=0.1005p
+ AD=0.0555p PS=1.34u PD=0.74u rfmode=0
M$3080 WBL[19] WWL[17] \$1481 GND sg13_hv_nmos L=0.45u W=0.15u AS=0.0555p
+ AD=0.1005p PS=0.74u PD=1.34u rfmode=0
M$3081 \$1404 WWL[16] WBL[20] GND sg13_hv_nmos L=0.45u W=0.15u AS=0.1005p
+ AD=0.0555p PS=1.34u PD=0.74u rfmode=0
M$3082 WBL[20] WWL[17] \$1482 GND sg13_hv_nmos L=0.45u W=0.15u AS=0.0555p
+ AD=0.1005p PS=0.74u PD=1.34u rfmode=0
M$3083 \$1405 WWL[16] WBL[21] GND sg13_hv_nmos L=0.45u W=0.15u AS=0.1005p
+ AD=0.0555p PS=1.34u PD=0.74u rfmode=0
M$3084 WBL[21] WWL[17] \$1483 GND sg13_hv_nmos L=0.45u W=0.15u AS=0.0555p
+ AD=0.1005p PS=0.74u PD=1.34u rfmode=0
M$3085 \$1406 WWL[16] WBL[22] GND sg13_hv_nmos L=0.45u W=0.15u AS=0.1005p
+ AD=0.0555p PS=1.34u PD=0.74u rfmode=0
M$3086 WBL[22] WWL[17] \$1484 GND sg13_hv_nmos L=0.45u W=0.15u AS=0.0555p
+ AD=0.1005p PS=0.74u PD=1.34u rfmode=0
M$3087 \$1407 WWL[16] WBL[23] GND sg13_hv_nmos L=0.45u W=0.15u AS=0.1005p
+ AD=0.0555p PS=1.34u PD=0.74u rfmode=0
M$3088 WBL[23] WWL[17] \$1485 GND sg13_hv_nmos L=0.45u W=0.15u AS=0.0555p
+ AD=0.1005p PS=0.74u PD=1.34u rfmode=0
M$3089 \$1408 WWL[16] WBL[24] GND sg13_hv_nmos L=0.45u W=0.15u AS=0.1005p
+ AD=0.0555p PS=1.34u PD=0.74u rfmode=0
M$3090 WBL[24] WWL[17] \$1486 GND sg13_hv_nmos L=0.45u W=0.15u AS=0.0555p
+ AD=0.1005p PS=0.74u PD=1.34u rfmode=0
M$3091 \$1409 WWL[16] WBL[25] GND sg13_hv_nmos L=0.45u W=0.15u AS=0.1005p
+ AD=0.0555p PS=1.34u PD=0.74u rfmode=0
M$3092 WBL[25] WWL[17] \$1487 GND sg13_hv_nmos L=0.45u W=0.15u AS=0.0555p
+ AD=0.1005p PS=0.74u PD=1.34u rfmode=0
M$3093 \$1410 WWL[16] WBL[26] GND sg13_hv_nmos L=0.45u W=0.15u AS=0.1005p
+ AD=0.0555p PS=1.34u PD=0.74u rfmode=0
M$3094 WBL[26] WWL[17] \$1488 GND sg13_hv_nmos L=0.45u W=0.15u AS=0.0555p
+ AD=0.1005p PS=0.74u PD=1.34u rfmode=0
M$3095 \$1411 WWL[16] WBL[27] GND sg13_hv_nmos L=0.45u W=0.15u AS=0.1005p
+ AD=0.0555p PS=1.34u PD=0.74u rfmode=0
M$3096 WBL[27] WWL[17] \$1489 GND sg13_hv_nmos L=0.45u W=0.15u AS=0.0555p
+ AD=0.1005p PS=0.74u PD=1.34u rfmode=0
M$3097 \$1412 WWL[16] WBL[28] GND sg13_hv_nmos L=0.45u W=0.15u AS=0.1005p
+ AD=0.0555p PS=1.34u PD=0.74u rfmode=0
M$3098 WBL[28] WWL[17] \$1490 GND sg13_hv_nmos L=0.45u W=0.15u AS=0.0555p
+ AD=0.1005p PS=0.74u PD=1.34u rfmode=0
M$3099 \$1413 WWL[16] WBL[29] GND sg13_hv_nmos L=0.45u W=0.15u AS=0.1005p
+ AD=0.0555p PS=1.34u PD=0.74u rfmode=0
M$3100 WBL[29] WWL[17] \$1491 GND sg13_hv_nmos L=0.45u W=0.15u AS=0.0555p
+ AD=0.1005p PS=0.74u PD=1.34u rfmode=0
M$3101 \$1414 WWL[16] WBL[30] GND sg13_hv_nmos L=0.45u W=0.15u AS=0.1005p
+ AD=0.0555p PS=1.34u PD=0.74u rfmode=0
M$3102 WBL[30] WWL[17] \$1492 GND sg13_hv_nmos L=0.45u W=0.15u AS=0.0555p
+ AD=0.1005p PS=0.74u PD=1.34u rfmode=0
M$3103 \$1415 WWL[16] WBL[31] GND sg13_hv_nmos L=0.45u W=0.15u AS=0.1005p
+ AD=0.0555p PS=1.34u PD=0.74u rfmode=0
M$3104 WBL[31] WWL[17] \$1493 GND sg13_hv_nmos L=0.45u W=0.15u AS=0.0555p
+ AD=0.1005p PS=0.74u PD=1.34u rfmode=0
M$3105 \$1416 WWL[16] WBL[32] GND sg13_hv_nmos L=0.45u W=0.15u AS=0.1005p
+ AD=0.0555p PS=1.34u PD=0.74u rfmode=0
M$3106 WBL[32] WWL[17] \$1494 GND sg13_hv_nmos L=0.45u W=0.15u AS=0.0555p
+ AD=0.1005p PS=0.74u PD=1.34u rfmode=0
M$3107 \$1417 WWL[16] WBL[33] GND sg13_hv_nmos L=0.45u W=0.15u AS=0.1005p
+ AD=0.0555p PS=1.34u PD=0.74u rfmode=0
M$3108 WBL[33] WWL[17] \$1495 GND sg13_hv_nmos L=0.45u W=0.15u AS=0.0555p
+ AD=0.1005p PS=0.74u PD=1.34u rfmode=0
M$3109 \$1418 WWL[16] WBL[34] GND sg13_hv_nmos L=0.45u W=0.15u AS=0.1005p
+ AD=0.0555p PS=1.34u PD=0.74u rfmode=0
M$3110 WBL[34] WWL[17] \$1496 GND sg13_hv_nmos L=0.45u W=0.15u AS=0.0555p
+ AD=0.1005p PS=0.74u PD=1.34u rfmode=0
M$3111 \$1419 WWL[16] WBL[35] GND sg13_hv_nmos L=0.45u W=0.15u AS=0.1005p
+ AD=0.0555p PS=1.34u PD=0.74u rfmode=0
M$3112 WBL[35] WWL[17] \$1497 GND sg13_hv_nmos L=0.45u W=0.15u AS=0.0555p
+ AD=0.1005p PS=0.74u PD=1.34u rfmode=0
M$3113 \$1420 WWL[16] WBL[36] GND sg13_hv_nmos L=0.45u W=0.15u AS=0.1005p
+ AD=0.0555p PS=1.34u PD=0.74u rfmode=0
M$3114 WBL[36] WWL[17] \$1498 GND sg13_hv_nmos L=0.45u W=0.15u AS=0.0555p
+ AD=0.1005p PS=0.74u PD=1.34u rfmode=0
M$3115 \$1421 WWL[16] WBL[37] GND sg13_hv_nmos L=0.45u W=0.15u AS=0.1005p
+ AD=0.0555p PS=1.34u PD=0.74u rfmode=0
M$3116 WBL[37] WWL[17] \$1499 GND sg13_hv_nmos L=0.45u W=0.15u AS=0.0555p
+ AD=0.1005p PS=0.74u PD=1.34u rfmode=0
M$3117 \$1547 WWL[18] WBL[0] GND sg13_hv_nmos L=0.45u W=0.15u AS=0.1005p
+ AD=0.0555p PS=1.34u PD=0.74u rfmode=0
M$3118 WBL[0] WWL[19] \$1625 GND sg13_hv_nmos L=0.45u W=0.15u AS=0.0555p
+ AD=0.1005p PS=0.74u PD=1.34u rfmode=0
M$3119 \$1548 WWL[18] WBL[1] GND sg13_hv_nmos L=0.45u W=0.15u AS=0.1005p
+ AD=0.0555p PS=1.34u PD=0.74u rfmode=0
M$3120 WBL[1] WWL[19] \$1626 GND sg13_hv_nmos L=0.45u W=0.15u AS=0.0555p
+ AD=0.1005p PS=0.74u PD=1.34u rfmode=0
M$3121 \$1549 WWL[18] WBL[2] GND sg13_hv_nmos L=0.45u W=0.15u AS=0.1005p
+ AD=0.0555p PS=1.34u PD=0.74u rfmode=0
M$3122 WBL[2] WWL[19] \$1627 GND sg13_hv_nmos L=0.45u W=0.15u AS=0.0555p
+ AD=0.1005p PS=0.74u PD=1.34u rfmode=0
M$3123 \$1550 WWL[18] WBL[3] GND sg13_hv_nmos L=0.45u W=0.15u AS=0.1005p
+ AD=0.0555p PS=1.34u PD=0.74u rfmode=0
M$3124 WBL[3] WWL[19] \$1628 GND sg13_hv_nmos L=0.45u W=0.15u AS=0.0555p
+ AD=0.1005p PS=0.74u PD=1.34u rfmode=0
M$3125 \$1551 WWL[18] WBL[4] GND sg13_hv_nmos L=0.45u W=0.15u AS=0.1005p
+ AD=0.0555p PS=1.34u PD=0.74u rfmode=0
M$3126 WBL[4] WWL[19] \$1629 GND sg13_hv_nmos L=0.45u W=0.15u AS=0.0555p
+ AD=0.1005p PS=0.74u PD=1.34u rfmode=0
M$3127 \$1552 WWL[18] WBL[5] GND sg13_hv_nmos L=0.45u W=0.15u AS=0.1005p
+ AD=0.0555p PS=1.34u PD=0.74u rfmode=0
M$3128 WBL[5] WWL[19] \$1630 GND sg13_hv_nmos L=0.45u W=0.15u AS=0.0555p
+ AD=0.1005p PS=0.74u PD=1.34u rfmode=0
M$3129 \$1553 WWL[18] WBL[6] GND sg13_hv_nmos L=0.45u W=0.15u AS=0.1005p
+ AD=0.0555p PS=1.34u PD=0.74u rfmode=0
M$3130 WBL[6] WWL[19] \$1631 GND sg13_hv_nmos L=0.45u W=0.15u AS=0.0555p
+ AD=0.1005p PS=0.74u PD=1.34u rfmode=0
M$3131 \$1554 WWL[18] WBL[7] GND sg13_hv_nmos L=0.45u W=0.15u AS=0.1005p
+ AD=0.0555p PS=1.34u PD=0.74u rfmode=0
M$3132 WBL[7] WWL[19] \$1632 GND sg13_hv_nmos L=0.45u W=0.15u AS=0.0555p
+ AD=0.1005p PS=0.74u PD=1.34u rfmode=0
M$3133 \$1555 WWL[18] WBL[8] GND sg13_hv_nmos L=0.45u W=0.15u AS=0.1005p
+ AD=0.0555p PS=1.34u PD=0.74u rfmode=0
M$3134 WBL[8] WWL[19] \$1633 GND sg13_hv_nmos L=0.45u W=0.15u AS=0.0555p
+ AD=0.1005p PS=0.74u PD=1.34u rfmode=0
M$3135 \$1556 WWL[18] WBL[9] GND sg13_hv_nmos L=0.45u W=0.15u AS=0.1005p
+ AD=0.0555p PS=1.34u PD=0.74u rfmode=0
M$3136 WBL[9] WWL[19] \$1634 GND sg13_hv_nmos L=0.45u W=0.15u AS=0.0555p
+ AD=0.1005p PS=0.74u PD=1.34u rfmode=0
M$3137 \$1557 WWL[18] WBL[10] GND sg13_hv_nmos L=0.45u W=0.15u AS=0.1005p
+ AD=0.0555p PS=1.34u PD=0.74u rfmode=0
M$3138 WBL[10] WWL[19] \$1635 GND sg13_hv_nmos L=0.45u W=0.15u AS=0.0555p
+ AD=0.1005p PS=0.74u PD=1.34u rfmode=0
M$3139 \$1558 WWL[18] WBL[11] GND sg13_hv_nmos L=0.45u W=0.15u AS=0.1005p
+ AD=0.0555p PS=1.34u PD=0.74u rfmode=0
M$3140 WBL[11] WWL[19] \$1636 GND sg13_hv_nmos L=0.45u W=0.15u AS=0.0555p
+ AD=0.1005p PS=0.74u PD=1.34u rfmode=0
M$3141 \$1559 WWL[18] WBL[12] GND sg13_hv_nmos L=0.45u W=0.15u AS=0.1005p
+ AD=0.0555p PS=1.34u PD=0.74u rfmode=0
M$3142 WBL[12] WWL[19] \$1637 GND sg13_hv_nmos L=0.45u W=0.15u AS=0.0555p
+ AD=0.1005p PS=0.74u PD=1.34u rfmode=0
M$3143 \$1560 WWL[18] WBL[13] GND sg13_hv_nmos L=0.45u W=0.15u AS=0.1005p
+ AD=0.0555p PS=1.34u PD=0.74u rfmode=0
M$3144 WBL[13] WWL[19] \$1638 GND sg13_hv_nmos L=0.45u W=0.15u AS=0.0555p
+ AD=0.1005p PS=0.74u PD=1.34u rfmode=0
M$3145 \$1561 WWL[18] WBL[14] GND sg13_hv_nmos L=0.45u W=0.15u AS=0.1005p
+ AD=0.0555p PS=1.34u PD=0.74u rfmode=0
M$3146 WBL[14] WWL[19] \$1639 GND sg13_hv_nmos L=0.45u W=0.15u AS=0.0555p
+ AD=0.1005p PS=0.74u PD=1.34u rfmode=0
M$3147 \$1562 WWL[18] WBL[15] GND sg13_hv_nmos L=0.45u W=0.15u AS=0.1005p
+ AD=0.0555p PS=1.34u PD=0.74u rfmode=0
M$3148 WBL[15] WWL[19] \$1640 GND sg13_hv_nmos L=0.45u W=0.15u AS=0.0555p
+ AD=0.1005p PS=0.74u PD=1.34u rfmode=0
M$3149 \$1563 WWL[18] WBL[16] GND sg13_hv_nmos L=0.45u W=0.15u AS=0.1005p
+ AD=0.0555p PS=1.34u PD=0.74u rfmode=0
M$3150 WBL[16] WWL[19] \$1641 GND sg13_hv_nmos L=0.45u W=0.15u AS=0.0555p
+ AD=0.1005p PS=0.74u PD=1.34u rfmode=0
M$3151 \$1564 WWL[18] WBL[17] GND sg13_hv_nmos L=0.45u W=0.15u AS=0.1005p
+ AD=0.0555p PS=1.34u PD=0.74u rfmode=0
M$3152 WBL[17] WWL[19] \$1642 GND sg13_hv_nmos L=0.45u W=0.15u AS=0.0555p
+ AD=0.1005p PS=0.74u PD=1.34u rfmode=0
M$3153 \$1565 WWL[18] WBL[18] GND sg13_hv_nmos L=0.45u W=0.15u AS=0.1005p
+ AD=0.0555p PS=1.34u PD=0.74u rfmode=0
M$3154 WBL[18] WWL[19] \$1643 GND sg13_hv_nmos L=0.45u W=0.15u AS=0.0555p
+ AD=0.1005p PS=0.74u PD=1.34u rfmode=0
M$3155 \$1566 WWL[18] WBL[19] GND sg13_hv_nmos L=0.45u W=0.15u AS=0.1005p
+ AD=0.0555p PS=1.34u PD=0.74u rfmode=0
M$3156 WBL[19] WWL[19] \$1644 GND sg13_hv_nmos L=0.45u W=0.15u AS=0.0555p
+ AD=0.1005p PS=0.74u PD=1.34u rfmode=0
M$3157 \$1567 WWL[18] WBL[20] GND sg13_hv_nmos L=0.45u W=0.15u AS=0.1005p
+ AD=0.0555p PS=1.34u PD=0.74u rfmode=0
M$3158 WBL[20] WWL[19] \$1645 GND sg13_hv_nmos L=0.45u W=0.15u AS=0.0555p
+ AD=0.1005p PS=0.74u PD=1.34u rfmode=0
M$3159 \$1568 WWL[18] WBL[21] GND sg13_hv_nmos L=0.45u W=0.15u AS=0.1005p
+ AD=0.0555p PS=1.34u PD=0.74u rfmode=0
M$3160 WBL[21] WWL[19] \$1646 GND sg13_hv_nmos L=0.45u W=0.15u AS=0.0555p
+ AD=0.1005p PS=0.74u PD=1.34u rfmode=0
M$3161 \$1569 WWL[18] WBL[22] GND sg13_hv_nmos L=0.45u W=0.15u AS=0.1005p
+ AD=0.0555p PS=1.34u PD=0.74u rfmode=0
M$3162 WBL[22] WWL[19] \$1647 GND sg13_hv_nmos L=0.45u W=0.15u AS=0.0555p
+ AD=0.1005p PS=0.74u PD=1.34u rfmode=0
M$3163 \$1570 WWL[18] WBL[23] GND sg13_hv_nmos L=0.45u W=0.15u AS=0.1005p
+ AD=0.0555p PS=1.34u PD=0.74u rfmode=0
M$3164 WBL[23] WWL[19] \$1648 GND sg13_hv_nmos L=0.45u W=0.15u AS=0.0555p
+ AD=0.1005p PS=0.74u PD=1.34u rfmode=0
M$3165 \$1571 WWL[18] WBL[24] GND sg13_hv_nmos L=0.45u W=0.15u AS=0.1005p
+ AD=0.0555p PS=1.34u PD=0.74u rfmode=0
M$3166 WBL[24] WWL[19] \$1649 GND sg13_hv_nmos L=0.45u W=0.15u AS=0.0555p
+ AD=0.1005p PS=0.74u PD=1.34u rfmode=0
M$3167 \$1572 WWL[18] WBL[25] GND sg13_hv_nmos L=0.45u W=0.15u AS=0.1005p
+ AD=0.0555p PS=1.34u PD=0.74u rfmode=0
M$3168 WBL[25] WWL[19] \$1650 GND sg13_hv_nmos L=0.45u W=0.15u AS=0.0555p
+ AD=0.1005p PS=0.74u PD=1.34u rfmode=0
M$3169 \$1573 WWL[18] WBL[26] GND sg13_hv_nmos L=0.45u W=0.15u AS=0.1005p
+ AD=0.0555p PS=1.34u PD=0.74u rfmode=0
M$3170 WBL[26] WWL[19] \$1651 GND sg13_hv_nmos L=0.45u W=0.15u AS=0.0555p
+ AD=0.1005p PS=0.74u PD=1.34u rfmode=0
M$3171 \$1574 WWL[18] WBL[27] GND sg13_hv_nmos L=0.45u W=0.15u AS=0.1005p
+ AD=0.0555p PS=1.34u PD=0.74u rfmode=0
M$3172 WBL[27] WWL[19] \$1652 GND sg13_hv_nmos L=0.45u W=0.15u AS=0.0555p
+ AD=0.1005p PS=0.74u PD=1.34u rfmode=0
M$3173 \$1575 WWL[18] WBL[28] GND sg13_hv_nmos L=0.45u W=0.15u AS=0.1005p
+ AD=0.0555p PS=1.34u PD=0.74u rfmode=0
M$3174 WBL[28] WWL[19] \$1653 GND sg13_hv_nmos L=0.45u W=0.15u AS=0.0555p
+ AD=0.1005p PS=0.74u PD=1.34u rfmode=0
M$3175 \$1576 WWL[18] WBL[29] GND sg13_hv_nmos L=0.45u W=0.15u AS=0.1005p
+ AD=0.0555p PS=1.34u PD=0.74u rfmode=0
M$3176 WBL[29] WWL[19] \$1654 GND sg13_hv_nmos L=0.45u W=0.15u AS=0.0555p
+ AD=0.1005p PS=0.74u PD=1.34u rfmode=0
M$3177 \$1577 WWL[18] WBL[30] GND sg13_hv_nmos L=0.45u W=0.15u AS=0.1005p
+ AD=0.0555p PS=1.34u PD=0.74u rfmode=0
M$3178 WBL[30] WWL[19] \$1655 GND sg13_hv_nmos L=0.45u W=0.15u AS=0.0555p
+ AD=0.1005p PS=0.74u PD=1.34u rfmode=0
M$3179 \$1578 WWL[18] WBL[31] GND sg13_hv_nmos L=0.45u W=0.15u AS=0.1005p
+ AD=0.0555p PS=1.34u PD=0.74u rfmode=0
M$3180 WBL[31] WWL[19] \$1656 GND sg13_hv_nmos L=0.45u W=0.15u AS=0.0555p
+ AD=0.1005p PS=0.74u PD=1.34u rfmode=0
M$3181 \$1579 WWL[18] WBL[32] GND sg13_hv_nmos L=0.45u W=0.15u AS=0.1005p
+ AD=0.0555p PS=1.34u PD=0.74u rfmode=0
M$3182 WBL[32] WWL[19] \$1657 GND sg13_hv_nmos L=0.45u W=0.15u AS=0.0555p
+ AD=0.1005p PS=0.74u PD=1.34u rfmode=0
M$3183 \$1580 WWL[18] WBL[33] GND sg13_hv_nmos L=0.45u W=0.15u AS=0.1005p
+ AD=0.0555p PS=1.34u PD=0.74u rfmode=0
M$3184 WBL[33] WWL[19] \$1658 GND sg13_hv_nmos L=0.45u W=0.15u AS=0.0555p
+ AD=0.1005p PS=0.74u PD=1.34u rfmode=0
M$3185 \$1581 WWL[18] WBL[34] GND sg13_hv_nmos L=0.45u W=0.15u AS=0.1005p
+ AD=0.0555p PS=1.34u PD=0.74u rfmode=0
M$3186 WBL[34] WWL[19] \$1659 GND sg13_hv_nmos L=0.45u W=0.15u AS=0.0555p
+ AD=0.1005p PS=0.74u PD=1.34u rfmode=0
M$3187 \$1582 WWL[18] WBL[35] GND sg13_hv_nmos L=0.45u W=0.15u AS=0.1005p
+ AD=0.0555p PS=1.34u PD=0.74u rfmode=0
M$3188 WBL[35] WWL[19] \$1660 GND sg13_hv_nmos L=0.45u W=0.15u AS=0.0555p
+ AD=0.1005p PS=0.74u PD=1.34u rfmode=0
M$3189 \$1583 WWL[18] WBL[36] GND sg13_hv_nmos L=0.45u W=0.15u AS=0.1005p
+ AD=0.0555p PS=1.34u PD=0.74u rfmode=0
M$3190 WBL[36] WWL[19] \$1661 GND sg13_hv_nmos L=0.45u W=0.15u AS=0.0555p
+ AD=0.1005p PS=0.74u PD=1.34u rfmode=0
M$3191 \$1584 WWL[18] WBL[37] GND sg13_hv_nmos L=0.45u W=0.15u AS=0.1005p
+ AD=0.0555p PS=1.34u PD=0.74u rfmode=0
M$3192 WBL[37] WWL[19] \$1662 GND sg13_hv_nmos L=0.45u W=0.15u AS=0.0555p
+ AD=0.1005p PS=0.74u PD=1.34u rfmode=0
M$3193 \$1710 WWL[20] WBL[0] GND sg13_hv_nmos L=0.45u W=0.15u AS=0.1005p
+ AD=0.0555p PS=1.34u PD=0.74u rfmode=0
M$3194 WBL[0] WWL[21] \$1788 GND sg13_hv_nmos L=0.45u W=0.15u AS=0.0555p
+ AD=0.1005p PS=0.74u PD=1.34u rfmode=0
M$3195 \$1711 WWL[20] WBL[1] GND sg13_hv_nmos L=0.45u W=0.15u AS=0.1005p
+ AD=0.0555p PS=1.34u PD=0.74u rfmode=0
M$3196 WBL[1] WWL[21] \$1789 GND sg13_hv_nmos L=0.45u W=0.15u AS=0.0555p
+ AD=0.1005p PS=0.74u PD=1.34u rfmode=0
M$3197 \$1712 WWL[20] WBL[2] GND sg13_hv_nmos L=0.45u W=0.15u AS=0.1005p
+ AD=0.0555p PS=1.34u PD=0.74u rfmode=0
M$3198 WBL[2] WWL[21] \$1790 GND sg13_hv_nmos L=0.45u W=0.15u AS=0.0555p
+ AD=0.1005p PS=0.74u PD=1.34u rfmode=0
M$3199 \$1713 WWL[20] WBL[3] GND sg13_hv_nmos L=0.45u W=0.15u AS=0.1005p
+ AD=0.0555p PS=1.34u PD=0.74u rfmode=0
M$3200 WBL[3] WWL[21] \$1791 GND sg13_hv_nmos L=0.45u W=0.15u AS=0.0555p
+ AD=0.1005p PS=0.74u PD=1.34u rfmode=0
M$3201 \$1714 WWL[20] WBL[4] GND sg13_hv_nmos L=0.45u W=0.15u AS=0.1005p
+ AD=0.0555p PS=1.34u PD=0.74u rfmode=0
M$3202 WBL[4] WWL[21] \$1792 GND sg13_hv_nmos L=0.45u W=0.15u AS=0.0555p
+ AD=0.1005p PS=0.74u PD=1.34u rfmode=0
M$3203 \$1715 WWL[20] WBL[5] GND sg13_hv_nmos L=0.45u W=0.15u AS=0.1005p
+ AD=0.0555p PS=1.34u PD=0.74u rfmode=0
M$3204 WBL[5] WWL[21] \$1793 GND sg13_hv_nmos L=0.45u W=0.15u AS=0.0555p
+ AD=0.1005p PS=0.74u PD=1.34u rfmode=0
M$3205 \$1716 WWL[20] WBL[6] GND sg13_hv_nmos L=0.45u W=0.15u AS=0.1005p
+ AD=0.0555p PS=1.34u PD=0.74u rfmode=0
M$3206 WBL[6] WWL[21] \$1794 GND sg13_hv_nmos L=0.45u W=0.15u AS=0.0555p
+ AD=0.1005p PS=0.74u PD=1.34u rfmode=0
M$3207 \$1717 WWL[20] WBL[7] GND sg13_hv_nmos L=0.45u W=0.15u AS=0.1005p
+ AD=0.0555p PS=1.34u PD=0.74u rfmode=0
M$3208 WBL[7] WWL[21] \$1795 GND sg13_hv_nmos L=0.45u W=0.15u AS=0.0555p
+ AD=0.1005p PS=0.74u PD=1.34u rfmode=0
M$3209 \$1718 WWL[20] WBL[8] GND sg13_hv_nmos L=0.45u W=0.15u AS=0.1005p
+ AD=0.0555p PS=1.34u PD=0.74u rfmode=0
M$3210 WBL[8] WWL[21] \$1796 GND sg13_hv_nmos L=0.45u W=0.15u AS=0.0555p
+ AD=0.1005p PS=0.74u PD=1.34u rfmode=0
M$3211 \$1719 WWL[20] WBL[9] GND sg13_hv_nmos L=0.45u W=0.15u AS=0.1005p
+ AD=0.0555p PS=1.34u PD=0.74u rfmode=0
M$3212 WBL[9] WWL[21] \$1797 GND sg13_hv_nmos L=0.45u W=0.15u AS=0.0555p
+ AD=0.1005p PS=0.74u PD=1.34u rfmode=0
M$3213 \$1720 WWL[20] WBL[10] GND sg13_hv_nmos L=0.45u W=0.15u AS=0.1005p
+ AD=0.0555p PS=1.34u PD=0.74u rfmode=0
M$3214 WBL[10] WWL[21] \$1798 GND sg13_hv_nmos L=0.45u W=0.15u AS=0.0555p
+ AD=0.1005p PS=0.74u PD=1.34u rfmode=0
M$3215 \$1721 WWL[20] WBL[11] GND sg13_hv_nmos L=0.45u W=0.15u AS=0.1005p
+ AD=0.0555p PS=1.34u PD=0.74u rfmode=0
M$3216 WBL[11] WWL[21] \$1799 GND sg13_hv_nmos L=0.45u W=0.15u AS=0.0555p
+ AD=0.1005p PS=0.74u PD=1.34u rfmode=0
M$3217 \$1722 WWL[20] WBL[12] GND sg13_hv_nmos L=0.45u W=0.15u AS=0.1005p
+ AD=0.0555p PS=1.34u PD=0.74u rfmode=0
M$3218 WBL[12] WWL[21] \$1800 GND sg13_hv_nmos L=0.45u W=0.15u AS=0.0555p
+ AD=0.1005p PS=0.74u PD=1.34u rfmode=0
M$3219 \$1723 WWL[20] WBL[13] GND sg13_hv_nmos L=0.45u W=0.15u AS=0.1005p
+ AD=0.0555p PS=1.34u PD=0.74u rfmode=0
M$3220 WBL[13] WWL[21] \$1801 GND sg13_hv_nmos L=0.45u W=0.15u AS=0.0555p
+ AD=0.1005p PS=0.74u PD=1.34u rfmode=0
M$3221 \$1724 WWL[20] WBL[14] GND sg13_hv_nmos L=0.45u W=0.15u AS=0.1005p
+ AD=0.0555p PS=1.34u PD=0.74u rfmode=0
M$3222 WBL[14] WWL[21] \$1802 GND sg13_hv_nmos L=0.45u W=0.15u AS=0.0555p
+ AD=0.1005p PS=0.74u PD=1.34u rfmode=0
M$3223 \$1725 WWL[20] WBL[15] GND sg13_hv_nmos L=0.45u W=0.15u AS=0.1005p
+ AD=0.0555p PS=1.34u PD=0.74u rfmode=0
M$3224 WBL[15] WWL[21] \$1803 GND sg13_hv_nmos L=0.45u W=0.15u AS=0.0555p
+ AD=0.1005p PS=0.74u PD=1.34u rfmode=0
M$3225 \$1726 WWL[20] WBL[16] GND sg13_hv_nmos L=0.45u W=0.15u AS=0.1005p
+ AD=0.0555p PS=1.34u PD=0.74u rfmode=0
M$3226 WBL[16] WWL[21] \$1804 GND sg13_hv_nmos L=0.45u W=0.15u AS=0.0555p
+ AD=0.1005p PS=0.74u PD=1.34u rfmode=0
M$3227 \$1727 WWL[20] WBL[17] GND sg13_hv_nmos L=0.45u W=0.15u AS=0.1005p
+ AD=0.0555p PS=1.34u PD=0.74u rfmode=0
M$3228 WBL[17] WWL[21] \$1805 GND sg13_hv_nmos L=0.45u W=0.15u AS=0.0555p
+ AD=0.1005p PS=0.74u PD=1.34u rfmode=0
M$3229 \$1728 WWL[20] WBL[18] GND sg13_hv_nmos L=0.45u W=0.15u AS=0.1005p
+ AD=0.0555p PS=1.34u PD=0.74u rfmode=0
M$3230 WBL[18] WWL[21] \$1806 GND sg13_hv_nmos L=0.45u W=0.15u AS=0.0555p
+ AD=0.1005p PS=0.74u PD=1.34u rfmode=0
M$3231 \$1729 WWL[20] WBL[19] GND sg13_hv_nmos L=0.45u W=0.15u AS=0.1005p
+ AD=0.0555p PS=1.34u PD=0.74u rfmode=0
M$3232 WBL[19] WWL[21] \$1807 GND sg13_hv_nmos L=0.45u W=0.15u AS=0.0555p
+ AD=0.1005p PS=0.74u PD=1.34u rfmode=0
M$3233 \$1730 WWL[20] WBL[20] GND sg13_hv_nmos L=0.45u W=0.15u AS=0.1005p
+ AD=0.0555p PS=1.34u PD=0.74u rfmode=0
M$3234 WBL[20] WWL[21] \$1808 GND sg13_hv_nmos L=0.45u W=0.15u AS=0.0555p
+ AD=0.1005p PS=0.74u PD=1.34u rfmode=0
M$3235 \$1731 WWL[20] WBL[21] GND sg13_hv_nmos L=0.45u W=0.15u AS=0.1005p
+ AD=0.0555p PS=1.34u PD=0.74u rfmode=0
M$3236 WBL[21] WWL[21] \$1809 GND sg13_hv_nmos L=0.45u W=0.15u AS=0.0555p
+ AD=0.1005p PS=0.74u PD=1.34u rfmode=0
M$3237 \$1732 WWL[20] WBL[22] GND sg13_hv_nmos L=0.45u W=0.15u AS=0.1005p
+ AD=0.0555p PS=1.34u PD=0.74u rfmode=0
M$3238 WBL[22] WWL[21] \$1810 GND sg13_hv_nmos L=0.45u W=0.15u AS=0.0555p
+ AD=0.1005p PS=0.74u PD=1.34u rfmode=0
M$3239 \$1733 WWL[20] WBL[23] GND sg13_hv_nmos L=0.45u W=0.15u AS=0.1005p
+ AD=0.0555p PS=1.34u PD=0.74u rfmode=0
M$3240 WBL[23] WWL[21] \$1811 GND sg13_hv_nmos L=0.45u W=0.15u AS=0.0555p
+ AD=0.1005p PS=0.74u PD=1.34u rfmode=0
M$3241 \$1734 WWL[20] WBL[24] GND sg13_hv_nmos L=0.45u W=0.15u AS=0.1005p
+ AD=0.0555p PS=1.34u PD=0.74u rfmode=0
M$3242 WBL[24] WWL[21] \$1812 GND sg13_hv_nmos L=0.45u W=0.15u AS=0.0555p
+ AD=0.1005p PS=0.74u PD=1.34u rfmode=0
M$3243 \$1735 WWL[20] WBL[25] GND sg13_hv_nmos L=0.45u W=0.15u AS=0.1005p
+ AD=0.0555p PS=1.34u PD=0.74u rfmode=0
M$3244 WBL[25] WWL[21] \$1813 GND sg13_hv_nmos L=0.45u W=0.15u AS=0.0555p
+ AD=0.1005p PS=0.74u PD=1.34u rfmode=0
M$3245 \$1736 WWL[20] WBL[26] GND sg13_hv_nmos L=0.45u W=0.15u AS=0.1005p
+ AD=0.0555p PS=1.34u PD=0.74u rfmode=0
M$3246 WBL[26] WWL[21] \$1814 GND sg13_hv_nmos L=0.45u W=0.15u AS=0.0555p
+ AD=0.1005p PS=0.74u PD=1.34u rfmode=0
M$3247 \$1737 WWL[20] WBL[27] GND sg13_hv_nmos L=0.45u W=0.15u AS=0.1005p
+ AD=0.0555p PS=1.34u PD=0.74u rfmode=0
M$3248 WBL[27] WWL[21] \$1815 GND sg13_hv_nmos L=0.45u W=0.15u AS=0.0555p
+ AD=0.1005p PS=0.74u PD=1.34u rfmode=0
M$3249 \$1738 WWL[20] WBL[28] GND sg13_hv_nmos L=0.45u W=0.15u AS=0.1005p
+ AD=0.0555p PS=1.34u PD=0.74u rfmode=0
M$3250 WBL[28] WWL[21] \$1816 GND sg13_hv_nmos L=0.45u W=0.15u AS=0.0555p
+ AD=0.1005p PS=0.74u PD=1.34u rfmode=0
M$3251 \$1739 WWL[20] WBL[29] GND sg13_hv_nmos L=0.45u W=0.15u AS=0.1005p
+ AD=0.0555p PS=1.34u PD=0.74u rfmode=0
M$3252 WBL[29] WWL[21] \$1817 GND sg13_hv_nmos L=0.45u W=0.15u AS=0.0555p
+ AD=0.1005p PS=0.74u PD=1.34u rfmode=0
M$3253 \$1740 WWL[20] WBL[30] GND sg13_hv_nmos L=0.45u W=0.15u AS=0.1005p
+ AD=0.0555p PS=1.34u PD=0.74u rfmode=0
M$3254 WBL[30] WWL[21] \$1818 GND sg13_hv_nmos L=0.45u W=0.15u AS=0.0555p
+ AD=0.1005p PS=0.74u PD=1.34u rfmode=0
M$3255 \$1741 WWL[20] WBL[31] GND sg13_hv_nmos L=0.45u W=0.15u AS=0.1005p
+ AD=0.0555p PS=1.34u PD=0.74u rfmode=0
M$3256 WBL[31] WWL[21] \$1819 GND sg13_hv_nmos L=0.45u W=0.15u AS=0.0555p
+ AD=0.1005p PS=0.74u PD=1.34u rfmode=0
M$3257 \$1742 WWL[20] WBL[32] GND sg13_hv_nmos L=0.45u W=0.15u AS=0.1005p
+ AD=0.0555p PS=1.34u PD=0.74u rfmode=0
M$3258 WBL[32] WWL[21] \$1820 GND sg13_hv_nmos L=0.45u W=0.15u AS=0.0555p
+ AD=0.1005p PS=0.74u PD=1.34u rfmode=0
M$3259 \$1743 WWL[20] WBL[33] GND sg13_hv_nmos L=0.45u W=0.15u AS=0.1005p
+ AD=0.0555p PS=1.34u PD=0.74u rfmode=0
M$3260 WBL[33] WWL[21] \$1821 GND sg13_hv_nmos L=0.45u W=0.15u AS=0.0555p
+ AD=0.1005p PS=0.74u PD=1.34u rfmode=0
M$3261 \$1744 WWL[20] WBL[34] GND sg13_hv_nmos L=0.45u W=0.15u AS=0.1005p
+ AD=0.0555p PS=1.34u PD=0.74u rfmode=0
M$3262 WBL[34] WWL[21] \$1822 GND sg13_hv_nmos L=0.45u W=0.15u AS=0.0555p
+ AD=0.1005p PS=0.74u PD=1.34u rfmode=0
M$3263 \$1745 WWL[20] WBL[35] GND sg13_hv_nmos L=0.45u W=0.15u AS=0.1005p
+ AD=0.0555p PS=1.34u PD=0.74u rfmode=0
M$3264 WBL[35] WWL[21] \$1823 GND sg13_hv_nmos L=0.45u W=0.15u AS=0.0555p
+ AD=0.1005p PS=0.74u PD=1.34u rfmode=0
M$3265 \$1746 WWL[20] WBL[36] GND sg13_hv_nmos L=0.45u W=0.15u AS=0.1005p
+ AD=0.0555p PS=1.34u PD=0.74u rfmode=0
M$3266 WBL[36] WWL[21] \$1824 GND sg13_hv_nmos L=0.45u W=0.15u AS=0.0555p
+ AD=0.1005p PS=0.74u PD=1.34u rfmode=0
M$3267 \$1747 WWL[20] WBL[37] GND sg13_hv_nmos L=0.45u W=0.15u AS=0.1005p
+ AD=0.0555p PS=1.34u PD=0.74u rfmode=0
M$3268 WBL[37] WWL[21] \$1825 GND sg13_hv_nmos L=0.45u W=0.15u AS=0.0555p
+ AD=0.1005p PS=0.74u PD=1.34u rfmode=0
M$3269 \$1873 WWL[22] WBL[0] GND sg13_hv_nmos L=0.45u W=0.15u AS=0.1005p
+ AD=0.0555p PS=1.34u PD=0.74u rfmode=0
M$3270 WBL[0] WWL[23] \$1951 GND sg13_hv_nmos L=0.45u W=0.15u AS=0.0555p
+ AD=0.1005p PS=0.74u PD=1.34u rfmode=0
M$3271 \$1874 WWL[22] WBL[1] GND sg13_hv_nmos L=0.45u W=0.15u AS=0.1005p
+ AD=0.0555p PS=1.34u PD=0.74u rfmode=0
M$3272 WBL[1] WWL[23] \$1952 GND sg13_hv_nmos L=0.45u W=0.15u AS=0.0555p
+ AD=0.1005p PS=0.74u PD=1.34u rfmode=0
M$3273 \$1875 WWL[22] WBL[2] GND sg13_hv_nmos L=0.45u W=0.15u AS=0.1005p
+ AD=0.0555p PS=1.34u PD=0.74u rfmode=0
M$3274 WBL[2] WWL[23] \$1953 GND sg13_hv_nmos L=0.45u W=0.15u AS=0.0555p
+ AD=0.1005p PS=0.74u PD=1.34u rfmode=0
M$3275 \$1876 WWL[22] WBL[3] GND sg13_hv_nmos L=0.45u W=0.15u AS=0.1005p
+ AD=0.0555p PS=1.34u PD=0.74u rfmode=0
M$3276 WBL[3] WWL[23] \$1954 GND sg13_hv_nmos L=0.45u W=0.15u AS=0.0555p
+ AD=0.1005p PS=0.74u PD=1.34u rfmode=0
M$3277 \$1877 WWL[22] WBL[4] GND sg13_hv_nmos L=0.45u W=0.15u AS=0.1005p
+ AD=0.0555p PS=1.34u PD=0.74u rfmode=0
M$3278 WBL[4] WWL[23] \$1955 GND sg13_hv_nmos L=0.45u W=0.15u AS=0.0555p
+ AD=0.1005p PS=0.74u PD=1.34u rfmode=0
M$3279 \$1878 WWL[22] WBL[5] GND sg13_hv_nmos L=0.45u W=0.15u AS=0.1005p
+ AD=0.0555p PS=1.34u PD=0.74u rfmode=0
M$3280 WBL[5] WWL[23] \$1956 GND sg13_hv_nmos L=0.45u W=0.15u AS=0.0555p
+ AD=0.1005p PS=0.74u PD=1.34u rfmode=0
M$3281 \$1879 WWL[22] WBL[6] GND sg13_hv_nmos L=0.45u W=0.15u AS=0.1005p
+ AD=0.0555p PS=1.34u PD=0.74u rfmode=0
M$3282 WBL[6] WWL[23] \$1957 GND sg13_hv_nmos L=0.45u W=0.15u AS=0.0555p
+ AD=0.1005p PS=0.74u PD=1.34u rfmode=0
M$3283 \$1880 WWL[22] WBL[7] GND sg13_hv_nmos L=0.45u W=0.15u AS=0.1005p
+ AD=0.0555p PS=1.34u PD=0.74u rfmode=0
M$3284 WBL[7] WWL[23] \$1958 GND sg13_hv_nmos L=0.45u W=0.15u AS=0.0555p
+ AD=0.1005p PS=0.74u PD=1.34u rfmode=0
M$3285 \$1881 WWL[22] WBL[8] GND sg13_hv_nmos L=0.45u W=0.15u AS=0.1005p
+ AD=0.0555p PS=1.34u PD=0.74u rfmode=0
M$3286 WBL[8] WWL[23] \$1959 GND sg13_hv_nmos L=0.45u W=0.15u AS=0.0555p
+ AD=0.1005p PS=0.74u PD=1.34u rfmode=0
M$3287 \$1882 WWL[22] WBL[9] GND sg13_hv_nmos L=0.45u W=0.15u AS=0.1005p
+ AD=0.0555p PS=1.34u PD=0.74u rfmode=0
M$3288 WBL[9] WWL[23] \$1960 GND sg13_hv_nmos L=0.45u W=0.15u AS=0.0555p
+ AD=0.1005p PS=0.74u PD=1.34u rfmode=0
M$3289 \$1883 WWL[22] WBL[10] GND sg13_hv_nmos L=0.45u W=0.15u AS=0.1005p
+ AD=0.0555p PS=1.34u PD=0.74u rfmode=0
M$3290 WBL[10] WWL[23] \$1961 GND sg13_hv_nmos L=0.45u W=0.15u AS=0.0555p
+ AD=0.1005p PS=0.74u PD=1.34u rfmode=0
M$3291 \$1884 WWL[22] WBL[11] GND sg13_hv_nmos L=0.45u W=0.15u AS=0.1005p
+ AD=0.0555p PS=1.34u PD=0.74u rfmode=0
M$3292 WBL[11] WWL[23] \$1962 GND sg13_hv_nmos L=0.45u W=0.15u AS=0.0555p
+ AD=0.1005p PS=0.74u PD=1.34u rfmode=0
M$3293 \$1885 WWL[22] WBL[12] GND sg13_hv_nmos L=0.45u W=0.15u AS=0.1005p
+ AD=0.0555p PS=1.34u PD=0.74u rfmode=0
M$3294 WBL[12] WWL[23] \$1963 GND sg13_hv_nmos L=0.45u W=0.15u AS=0.0555p
+ AD=0.1005p PS=0.74u PD=1.34u rfmode=0
M$3295 \$1886 WWL[22] WBL[13] GND sg13_hv_nmos L=0.45u W=0.15u AS=0.1005p
+ AD=0.0555p PS=1.34u PD=0.74u rfmode=0
M$3296 WBL[13] WWL[23] \$1964 GND sg13_hv_nmos L=0.45u W=0.15u AS=0.0555p
+ AD=0.1005p PS=0.74u PD=1.34u rfmode=0
M$3297 \$1887 WWL[22] WBL[14] GND sg13_hv_nmos L=0.45u W=0.15u AS=0.1005p
+ AD=0.0555p PS=1.34u PD=0.74u rfmode=0
M$3298 WBL[14] WWL[23] \$1965 GND sg13_hv_nmos L=0.45u W=0.15u AS=0.0555p
+ AD=0.1005p PS=0.74u PD=1.34u rfmode=0
M$3299 \$1888 WWL[22] WBL[15] GND sg13_hv_nmos L=0.45u W=0.15u AS=0.1005p
+ AD=0.0555p PS=1.34u PD=0.74u rfmode=0
M$3300 WBL[15] WWL[23] \$1966 GND sg13_hv_nmos L=0.45u W=0.15u AS=0.0555p
+ AD=0.1005p PS=0.74u PD=1.34u rfmode=0
M$3301 \$1889 WWL[22] WBL[16] GND sg13_hv_nmos L=0.45u W=0.15u AS=0.1005p
+ AD=0.0555p PS=1.34u PD=0.74u rfmode=0
M$3302 WBL[16] WWL[23] \$1967 GND sg13_hv_nmos L=0.45u W=0.15u AS=0.0555p
+ AD=0.1005p PS=0.74u PD=1.34u rfmode=0
M$3303 \$1890 WWL[22] WBL[17] GND sg13_hv_nmos L=0.45u W=0.15u AS=0.1005p
+ AD=0.0555p PS=1.34u PD=0.74u rfmode=0
M$3304 WBL[17] WWL[23] \$1968 GND sg13_hv_nmos L=0.45u W=0.15u AS=0.0555p
+ AD=0.1005p PS=0.74u PD=1.34u rfmode=0
M$3305 \$1891 WWL[22] WBL[18] GND sg13_hv_nmos L=0.45u W=0.15u AS=0.1005p
+ AD=0.0555p PS=1.34u PD=0.74u rfmode=0
M$3306 WBL[18] WWL[23] \$1969 GND sg13_hv_nmos L=0.45u W=0.15u AS=0.0555p
+ AD=0.1005p PS=0.74u PD=1.34u rfmode=0
M$3307 \$1892 WWL[22] WBL[19] GND sg13_hv_nmos L=0.45u W=0.15u AS=0.1005p
+ AD=0.0555p PS=1.34u PD=0.74u rfmode=0
M$3308 WBL[19] WWL[23] \$1970 GND sg13_hv_nmos L=0.45u W=0.15u AS=0.0555p
+ AD=0.1005p PS=0.74u PD=1.34u rfmode=0
M$3309 \$1893 WWL[22] WBL[20] GND sg13_hv_nmos L=0.45u W=0.15u AS=0.1005p
+ AD=0.0555p PS=1.34u PD=0.74u rfmode=0
M$3310 WBL[20] WWL[23] \$1971 GND sg13_hv_nmos L=0.45u W=0.15u AS=0.0555p
+ AD=0.1005p PS=0.74u PD=1.34u rfmode=0
M$3311 \$1894 WWL[22] WBL[21] GND sg13_hv_nmos L=0.45u W=0.15u AS=0.1005p
+ AD=0.0555p PS=1.34u PD=0.74u rfmode=0
M$3312 WBL[21] WWL[23] \$1972 GND sg13_hv_nmos L=0.45u W=0.15u AS=0.0555p
+ AD=0.1005p PS=0.74u PD=1.34u rfmode=0
M$3313 \$1895 WWL[22] WBL[22] GND sg13_hv_nmos L=0.45u W=0.15u AS=0.1005p
+ AD=0.0555p PS=1.34u PD=0.74u rfmode=0
M$3314 WBL[22] WWL[23] \$1973 GND sg13_hv_nmos L=0.45u W=0.15u AS=0.0555p
+ AD=0.1005p PS=0.74u PD=1.34u rfmode=0
M$3315 \$1896 WWL[22] WBL[23] GND sg13_hv_nmos L=0.45u W=0.15u AS=0.1005p
+ AD=0.0555p PS=1.34u PD=0.74u rfmode=0
M$3316 WBL[23] WWL[23] \$1974 GND sg13_hv_nmos L=0.45u W=0.15u AS=0.0555p
+ AD=0.1005p PS=0.74u PD=1.34u rfmode=0
M$3317 \$1897 WWL[22] WBL[24] GND sg13_hv_nmos L=0.45u W=0.15u AS=0.1005p
+ AD=0.0555p PS=1.34u PD=0.74u rfmode=0
M$3318 WBL[24] WWL[23] \$1975 GND sg13_hv_nmos L=0.45u W=0.15u AS=0.0555p
+ AD=0.1005p PS=0.74u PD=1.34u rfmode=0
M$3319 \$1898 WWL[22] WBL[25] GND sg13_hv_nmos L=0.45u W=0.15u AS=0.1005p
+ AD=0.0555p PS=1.34u PD=0.74u rfmode=0
M$3320 WBL[25] WWL[23] \$1976 GND sg13_hv_nmos L=0.45u W=0.15u AS=0.0555p
+ AD=0.1005p PS=0.74u PD=1.34u rfmode=0
M$3321 \$1899 WWL[22] WBL[26] GND sg13_hv_nmos L=0.45u W=0.15u AS=0.1005p
+ AD=0.0555p PS=1.34u PD=0.74u rfmode=0
M$3322 WBL[26] WWL[23] \$1977 GND sg13_hv_nmos L=0.45u W=0.15u AS=0.0555p
+ AD=0.1005p PS=0.74u PD=1.34u rfmode=0
M$3323 \$1900 WWL[22] WBL[27] GND sg13_hv_nmos L=0.45u W=0.15u AS=0.1005p
+ AD=0.0555p PS=1.34u PD=0.74u rfmode=0
M$3324 WBL[27] WWL[23] \$1978 GND sg13_hv_nmos L=0.45u W=0.15u AS=0.0555p
+ AD=0.1005p PS=0.74u PD=1.34u rfmode=0
M$3325 \$1901 WWL[22] WBL[28] GND sg13_hv_nmos L=0.45u W=0.15u AS=0.1005p
+ AD=0.0555p PS=1.34u PD=0.74u rfmode=0
M$3326 WBL[28] WWL[23] \$1979 GND sg13_hv_nmos L=0.45u W=0.15u AS=0.0555p
+ AD=0.1005p PS=0.74u PD=1.34u rfmode=0
M$3327 \$1902 WWL[22] WBL[29] GND sg13_hv_nmos L=0.45u W=0.15u AS=0.1005p
+ AD=0.0555p PS=1.34u PD=0.74u rfmode=0
M$3328 WBL[29] WWL[23] \$1980 GND sg13_hv_nmos L=0.45u W=0.15u AS=0.0555p
+ AD=0.1005p PS=0.74u PD=1.34u rfmode=0
M$3329 \$1903 WWL[22] WBL[30] GND sg13_hv_nmos L=0.45u W=0.15u AS=0.1005p
+ AD=0.0555p PS=1.34u PD=0.74u rfmode=0
M$3330 WBL[30] WWL[23] \$1981 GND sg13_hv_nmos L=0.45u W=0.15u AS=0.0555p
+ AD=0.1005p PS=0.74u PD=1.34u rfmode=0
M$3331 \$1904 WWL[22] WBL[31] GND sg13_hv_nmos L=0.45u W=0.15u AS=0.1005p
+ AD=0.0555p PS=1.34u PD=0.74u rfmode=0
M$3332 WBL[31] WWL[23] \$1982 GND sg13_hv_nmos L=0.45u W=0.15u AS=0.0555p
+ AD=0.1005p PS=0.74u PD=1.34u rfmode=0
M$3333 \$1905 WWL[22] WBL[32] GND sg13_hv_nmos L=0.45u W=0.15u AS=0.1005p
+ AD=0.0555p PS=1.34u PD=0.74u rfmode=0
M$3334 WBL[32] WWL[23] \$1983 GND sg13_hv_nmos L=0.45u W=0.15u AS=0.0555p
+ AD=0.1005p PS=0.74u PD=1.34u rfmode=0
M$3335 \$1906 WWL[22] WBL[33] GND sg13_hv_nmos L=0.45u W=0.15u AS=0.1005p
+ AD=0.0555p PS=1.34u PD=0.74u rfmode=0
M$3336 WBL[33] WWL[23] \$1984 GND sg13_hv_nmos L=0.45u W=0.15u AS=0.0555p
+ AD=0.1005p PS=0.74u PD=1.34u rfmode=0
M$3337 \$1907 WWL[22] WBL[34] GND sg13_hv_nmos L=0.45u W=0.15u AS=0.1005p
+ AD=0.0555p PS=1.34u PD=0.74u rfmode=0
M$3338 WBL[34] WWL[23] \$1985 GND sg13_hv_nmos L=0.45u W=0.15u AS=0.0555p
+ AD=0.1005p PS=0.74u PD=1.34u rfmode=0
M$3339 \$1908 WWL[22] WBL[35] GND sg13_hv_nmos L=0.45u W=0.15u AS=0.1005p
+ AD=0.0555p PS=1.34u PD=0.74u rfmode=0
M$3340 WBL[35] WWL[23] \$1986 GND sg13_hv_nmos L=0.45u W=0.15u AS=0.0555p
+ AD=0.1005p PS=0.74u PD=1.34u rfmode=0
M$3341 \$1909 WWL[22] WBL[36] GND sg13_hv_nmos L=0.45u W=0.15u AS=0.1005p
+ AD=0.0555p PS=1.34u PD=0.74u rfmode=0
M$3342 WBL[36] WWL[23] \$1987 GND sg13_hv_nmos L=0.45u W=0.15u AS=0.0555p
+ AD=0.1005p PS=0.74u PD=1.34u rfmode=0
M$3343 \$1910 WWL[22] WBL[37] GND sg13_hv_nmos L=0.45u W=0.15u AS=0.1005p
+ AD=0.0555p PS=1.34u PD=0.74u rfmode=0
M$3344 WBL[37] WWL[23] \$1988 GND sg13_hv_nmos L=0.45u W=0.15u AS=0.0555p
+ AD=0.1005p PS=0.74u PD=1.34u rfmode=0
M$3345 \$2036 WWL[24] WBL[0] GND sg13_hv_nmos L=0.45u W=0.15u AS=0.1005p
+ AD=0.0555p PS=1.34u PD=0.74u rfmode=0
M$3346 WBL[0] WWL[25] \$2114 GND sg13_hv_nmos L=0.45u W=0.15u AS=0.0555p
+ AD=0.1005p PS=0.74u PD=1.34u rfmode=0
M$3347 \$2037 WWL[24] WBL[1] GND sg13_hv_nmos L=0.45u W=0.15u AS=0.1005p
+ AD=0.0555p PS=1.34u PD=0.74u rfmode=0
M$3348 WBL[1] WWL[25] \$2115 GND sg13_hv_nmos L=0.45u W=0.15u AS=0.0555p
+ AD=0.1005p PS=0.74u PD=1.34u rfmode=0
M$3349 \$2038 WWL[24] WBL[2] GND sg13_hv_nmos L=0.45u W=0.15u AS=0.1005p
+ AD=0.0555p PS=1.34u PD=0.74u rfmode=0
M$3350 WBL[2] WWL[25] \$2116 GND sg13_hv_nmos L=0.45u W=0.15u AS=0.0555p
+ AD=0.1005p PS=0.74u PD=1.34u rfmode=0
M$3351 \$2039 WWL[24] WBL[3] GND sg13_hv_nmos L=0.45u W=0.15u AS=0.1005p
+ AD=0.0555p PS=1.34u PD=0.74u rfmode=0
M$3352 WBL[3] WWL[25] \$2117 GND sg13_hv_nmos L=0.45u W=0.15u AS=0.0555p
+ AD=0.1005p PS=0.74u PD=1.34u rfmode=0
M$3353 \$2040 WWL[24] WBL[4] GND sg13_hv_nmos L=0.45u W=0.15u AS=0.1005p
+ AD=0.0555p PS=1.34u PD=0.74u rfmode=0
M$3354 WBL[4] WWL[25] \$2118 GND sg13_hv_nmos L=0.45u W=0.15u AS=0.0555p
+ AD=0.1005p PS=0.74u PD=1.34u rfmode=0
M$3355 \$2041 WWL[24] WBL[5] GND sg13_hv_nmos L=0.45u W=0.15u AS=0.1005p
+ AD=0.0555p PS=1.34u PD=0.74u rfmode=0
M$3356 WBL[5] WWL[25] \$2119 GND sg13_hv_nmos L=0.45u W=0.15u AS=0.0555p
+ AD=0.1005p PS=0.74u PD=1.34u rfmode=0
M$3357 \$2042 WWL[24] WBL[6] GND sg13_hv_nmos L=0.45u W=0.15u AS=0.1005p
+ AD=0.0555p PS=1.34u PD=0.74u rfmode=0
M$3358 WBL[6] WWL[25] \$2120 GND sg13_hv_nmos L=0.45u W=0.15u AS=0.0555p
+ AD=0.1005p PS=0.74u PD=1.34u rfmode=0
M$3359 \$2043 WWL[24] WBL[7] GND sg13_hv_nmos L=0.45u W=0.15u AS=0.1005p
+ AD=0.0555p PS=1.34u PD=0.74u rfmode=0
M$3360 WBL[7] WWL[25] \$2121 GND sg13_hv_nmos L=0.45u W=0.15u AS=0.0555p
+ AD=0.1005p PS=0.74u PD=1.34u rfmode=0
M$3361 \$2044 WWL[24] WBL[8] GND sg13_hv_nmos L=0.45u W=0.15u AS=0.1005p
+ AD=0.0555p PS=1.34u PD=0.74u rfmode=0
M$3362 WBL[8] WWL[25] \$2122 GND sg13_hv_nmos L=0.45u W=0.15u AS=0.0555p
+ AD=0.1005p PS=0.74u PD=1.34u rfmode=0
M$3363 \$2045 WWL[24] WBL[9] GND sg13_hv_nmos L=0.45u W=0.15u AS=0.1005p
+ AD=0.0555p PS=1.34u PD=0.74u rfmode=0
M$3364 WBL[9] WWL[25] \$2123 GND sg13_hv_nmos L=0.45u W=0.15u AS=0.0555p
+ AD=0.1005p PS=0.74u PD=1.34u rfmode=0
M$3365 \$2046 WWL[24] WBL[10] GND sg13_hv_nmos L=0.45u W=0.15u AS=0.1005p
+ AD=0.0555p PS=1.34u PD=0.74u rfmode=0
M$3366 WBL[10] WWL[25] \$2124 GND sg13_hv_nmos L=0.45u W=0.15u AS=0.0555p
+ AD=0.1005p PS=0.74u PD=1.34u rfmode=0
M$3367 \$2047 WWL[24] WBL[11] GND sg13_hv_nmos L=0.45u W=0.15u AS=0.1005p
+ AD=0.0555p PS=1.34u PD=0.74u rfmode=0
M$3368 WBL[11] WWL[25] \$2125 GND sg13_hv_nmos L=0.45u W=0.15u AS=0.0555p
+ AD=0.1005p PS=0.74u PD=1.34u rfmode=0
M$3369 \$2048 WWL[24] WBL[12] GND sg13_hv_nmos L=0.45u W=0.15u AS=0.1005p
+ AD=0.0555p PS=1.34u PD=0.74u rfmode=0
M$3370 WBL[12] WWL[25] \$2126 GND sg13_hv_nmos L=0.45u W=0.15u AS=0.0555p
+ AD=0.1005p PS=0.74u PD=1.34u rfmode=0
M$3371 \$2049 WWL[24] WBL[13] GND sg13_hv_nmos L=0.45u W=0.15u AS=0.1005p
+ AD=0.0555p PS=1.34u PD=0.74u rfmode=0
M$3372 WBL[13] WWL[25] \$2127 GND sg13_hv_nmos L=0.45u W=0.15u AS=0.0555p
+ AD=0.1005p PS=0.74u PD=1.34u rfmode=0
M$3373 \$2050 WWL[24] WBL[14] GND sg13_hv_nmos L=0.45u W=0.15u AS=0.1005p
+ AD=0.0555p PS=1.34u PD=0.74u rfmode=0
M$3374 WBL[14] WWL[25] \$2128 GND sg13_hv_nmos L=0.45u W=0.15u AS=0.0555p
+ AD=0.1005p PS=0.74u PD=1.34u rfmode=0
M$3375 \$2051 WWL[24] WBL[15] GND sg13_hv_nmos L=0.45u W=0.15u AS=0.1005p
+ AD=0.0555p PS=1.34u PD=0.74u rfmode=0
M$3376 WBL[15] WWL[25] \$2129 GND sg13_hv_nmos L=0.45u W=0.15u AS=0.0555p
+ AD=0.1005p PS=0.74u PD=1.34u rfmode=0
M$3377 \$2052 WWL[24] WBL[16] GND sg13_hv_nmos L=0.45u W=0.15u AS=0.1005p
+ AD=0.0555p PS=1.34u PD=0.74u rfmode=0
M$3378 WBL[16] WWL[25] \$2130 GND sg13_hv_nmos L=0.45u W=0.15u AS=0.0555p
+ AD=0.1005p PS=0.74u PD=1.34u rfmode=0
M$3379 \$2053 WWL[24] WBL[17] GND sg13_hv_nmos L=0.45u W=0.15u AS=0.1005p
+ AD=0.0555p PS=1.34u PD=0.74u rfmode=0
M$3380 WBL[17] WWL[25] \$2131 GND sg13_hv_nmos L=0.45u W=0.15u AS=0.0555p
+ AD=0.1005p PS=0.74u PD=1.34u rfmode=0
M$3381 \$2054 WWL[24] WBL[18] GND sg13_hv_nmos L=0.45u W=0.15u AS=0.1005p
+ AD=0.0555p PS=1.34u PD=0.74u rfmode=0
M$3382 WBL[18] WWL[25] \$2132 GND sg13_hv_nmos L=0.45u W=0.15u AS=0.0555p
+ AD=0.1005p PS=0.74u PD=1.34u rfmode=0
M$3383 \$2055 WWL[24] WBL[19] GND sg13_hv_nmos L=0.45u W=0.15u AS=0.1005p
+ AD=0.0555p PS=1.34u PD=0.74u rfmode=0
M$3384 WBL[19] WWL[25] \$2133 GND sg13_hv_nmos L=0.45u W=0.15u AS=0.0555p
+ AD=0.1005p PS=0.74u PD=1.34u rfmode=0
M$3385 \$2056 WWL[24] WBL[20] GND sg13_hv_nmos L=0.45u W=0.15u AS=0.1005p
+ AD=0.0555p PS=1.34u PD=0.74u rfmode=0
M$3386 WBL[20] WWL[25] \$2134 GND sg13_hv_nmos L=0.45u W=0.15u AS=0.0555p
+ AD=0.1005p PS=0.74u PD=1.34u rfmode=0
M$3387 \$2057 WWL[24] WBL[21] GND sg13_hv_nmos L=0.45u W=0.15u AS=0.1005p
+ AD=0.0555p PS=1.34u PD=0.74u rfmode=0
M$3388 WBL[21] WWL[25] \$2135 GND sg13_hv_nmos L=0.45u W=0.15u AS=0.0555p
+ AD=0.1005p PS=0.74u PD=1.34u rfmode=0
M$3389 \$2058 WWL[24] WBL[22] GND sg13_hv_nmos L=0.45u W=0.15u AS=0.1005p
+ AD=0.0555p PS=1.34u PD=0.74u rfmode=0
M$3390 WBL[22] WWL[25] \$2136 GND sg13_hv_nmos L=0.45u W=0.15u AS=0.0555p
+ AD=0.1005p PS=0.74u PD=1.34u rfmode=0
M$3391 \$2059 WWL[24] WBL[23] GND sg13_hv_nmos L=0.45u W=0.15u AS=0.1005p
+ AD=0.0555p PS=1.34u PD=0.74u rfmode=0
M$3392 WBL[23] WWL[25] \$2137 GND sg13_hv_nmos L=0.45u W=0.15u AS=0.0555p
+ AD=0.1005p PS=0.74u PD=1.34u rfmode=0
M$3393 \$2060 WWL[24] WBL[24] GND sg13_hv_nmos L=0.45u W=0.15u AS=0.1005p
+ AD=0.0555p PS=1.34u PD=0.74u rfmode=0
M$3394 WBL[24] WWL[25] \$2138 GND sg13_hv_nmos L=0.45u W=0.15u AS=0.0555p
+ AD=0.1005p PS=0.74u PD=1.34u rfmode=0
M$3395 \$2061 WWL[24] WBL[25] GND sg13_hv_nmos L=0.45u W=0.15u AS=0.1005p
+ AD=0.0555p PS=1.34u PD=0.74u rfmode=0
M$3396 WBL[25] WWL[25] \$2139 GND sg13_hv_nmos L=0.45u W=0.15u AS=0.0555p
+ AD=0.1005p PS=0.74u PD=1.34u rfmode=0
M$3397 \$2062 WWL[24] WBL[26] GND sg13_hv_nmos L=0.45u W=0.15u AS=0.1005p
+ AD=0.0555p PS=1.34u PD=0.74u rfmode=0
M$3398 WBL[26] WWL[25] \$2140 GND sg13_hv_nmos L=0.45u W=0.15u AS=0.0555p
+ AD=0.1005p PS=0.74u PD=1.34u rfmode=0
M$3399 \$2063 WWL[24] WBL[27] GND sg13_hv_nmos L=0.45u W=0.15u AS=0.1005p
+ AD=0.0555p PS=1.34u PD=0.74u rfmode=0
M$3400 WBL[27] WWL[25] \$2141 GND sg13_hv_nmos L=0.45u W=0.15u AS=0.0555p
+ AD=0.1005p PS=0.74u PD=1.34u rfmode=0
M$3401 \$2064 WWL[24] WBL[28] GND sg13_hv_nmos L=0.45u W=0.15u AS=0.1005p
+ AD=0.0555p PS=1.34u PD=0.74u rfmode=0
M$3402 WBL[28] WWL[25] \$2142 GND sg13_hv_nmos L=0.45u W=0.15u AS=0.0555p
+ AD=0.1005p PS=0.74u PD=1.34u rfmode=0
M$3403 \$2065 WWL[24] WBL[29] GND sg13_hv_nmos L=0.45u W=0.15u AS=0.1005p
+ AD=0.0555p PS=1.34u PD=0.74u rfmode=0
M$3404 WBL[29] WWL[25] \$2143 GND sg13_hv_nmos L=0.45u W=0.15u AS=0.0555p
+ AD=0.1005p PS=0.74u PD=1.34u rfmode=0
M$3405 \$2066 WWL[24] WBL[30] GND sg13_hv_nmos L=0.45u W=0.15u AS=0.1005p
+ AD=0.0555p PS=1.34u PD=0.74u rfmode=0
M$3406 WBL[30] WWL[25] \$2144 GND sg13_hv_nmos L=0.45u W=0.15u AS=0.0555p
+ AD=0.1005p PS=0.74u PD=1.34u rfmode=0
M$3407 \$2067 WWL[24] WBL[31] GND sg13_hv_nmos L=0.45u W=0.15u AS=0.1005p
+ AD=0.0555p PS=1.34u PD=0.74u rfmode=0
M$3408 WBL[31] WWL[25] \$2145 GND sg13_hv_nmos L=0.45u W=0.15u AS=0.0555p
+ AD=0.1005p PS=0.74u PD=1.34u rfmode=0
M$3409 \$2068 WWL[24] WBL[32] GND sg13_hv_nmos L=0.45u W=0.15u AS=0.1005p
+ AD=0.0555p PS=1.34u PD=0.74u rfmode=0
M$3410 WBL[32] WWL[25] \$2146 GND sg13_hv_nmos L=0.45u W=0.15u AS=0.0555p
+ AD=0.1005p PS=0.74u PD=1.34u rfmode=0
M$3411 \$2069 WWL[24] WBL[33] GND sg13_hv_nmos L=0.45u W=0.15u AS=0.1005p
+ AD=0.0555p PS=1.34u PD=0.74u rfmode=0
M$3412 WBL[33] WWL[25] \$2147 GND sg13_hv_nmos L=0.45u W=0.15u AS=0.0555p
+ AD=0.1005p PS=0.74u PD=1.34u rfmode=0
M$3413 \$2070 WWL[24] WBL[34] GND sg13_hv_nmos L=0.45u W=0.15u AS=0.1005p
+ AD=0.0555p PS=1.34u PD=0.74u rfmode=0
M$3414 WBL[34] WWL[25] \$2148 GND sg13_hv_nmos L=0.45u W=0.15u AS=0.0555p
+ AD=0.1005p PS=0.74u PD=1.34u rfmode=0
M$3415 \$2071 WWL[24] WBL[35] GND sg13_hv_nmos L=0.45u W=0.15u AS=0.1005p
+ AD=0.0555p PS=1.34u PD=0.74u rfmode=0
M$3416 WBL[35] WWL[25] \$2149 GND sg13_hv_nmos L=0.45u W=0.15u AS=0.0555p
+ AD=0.1005p PS=0.74u PD=1.34u rfmode=0
M$3417 \$2072 WWL[24] WBL[36] GND sg13_hv_nmos L=0.45u W=0.15u AS=0.1005p
+ AD=0.0555p PS=1.34u PD=0.74u rfmode=0
M$3418 WBL[36] WWL[25] \$2150 GND sg13_hv_nmos L=0.45u W=0.15u AS=0.0555p
+ AD=0.1005p PS=0.74u PD=1.34u rfmode=0
M$3419 \$2073 WWL[24] WBL[37] GND sg13_hv_nmos L=0.45u W=0.15u AS=0.1005p
+ AD=0.0555p PS=1.34u PD=0.74u rfmode=0
M$3420 WBL[37] WWL[25] \$2151 GND sg13_hv_nmos L=0.45u W=0.15u AS=0.0555p
+ AD=0.1005p PS=0.74u PD=1.34u rfmode=0
M$3421 \$2199 WWL[26] WBL[0] GND sg13_hv_nmos L=0.45u W=0.15u AS=0.1005p
+ AD=0.0555p PS=1.34u PD=0.74u rfmode=0
M$3422 WBL[0] WWL[27] \$2277 GND sg13_hv_nmos L=0.45u W=0.15u AS=0.0555p
+ AD=0.1005p PS=0.74u PD=1.34u rfmode=0
M$3423 \$2200 WWL[26] WBL[1] GND sg13_hv_nmos L=0.45u W=0.15u AS=0.1005p
+ AD=0.0555p PS=1.34u PD=0.74u rfmode=0
M$3424 WBL[1] WWL[27] \$2278 GND sg13_hv_nmos L=0.45u W=0.15u AS=0.0555p
+ AD=0.1005p PS=0.74u PD=1.34u rfmode=0
M$3425 \$2201 WWL[26] WBL[2] GND sg13_hv_nmos L=0.45u W=0.15u AS=0.1005p
+ AD=0.0555p PS=1.34u PD=0.74u rfmode=0
M$3426 WBL[2] WWL[27] \$2279 GND sg13_hv_nmos L=0.45u W=0.15u AS=0.0555p
+ AD=0.1005p PS=0.74u PD=1.34u rfmode=0
M$3427 \$2202 WWL[26] WBL[3] GND sg13_hv_nmos L=0.45u W=0.15u AS=0.1005p
+ AD=0.0555p PS=1.34u PD=0.74u rfmode=0
M$3428 WBL[3] WWL[27] \$2280 GND sg13_hv_nmos L=0.45u W=0.15u AS=0.0555p
+ AD=0.1005p PS=0.74u PD=1.34u rfmode=0
M$3429 \$2203 WWL[26] WBL[4] GND sg13_hv_nmos L=0.45u W=0.15u AS=0.1005p
+ AD=0.0555p PS=1.34u PD=0.74u rfmode=0
M$3430 WBL[4] WWL[27] \$2281 GND sg13_hv_nmos L=0.45u W=0.15u AS=0.0555p
+ AD=0.1005p PS=0.74u PD=1.34u rfmode=0
M$3431 \$2204 WWL[26] WBL[5] GND sg13_hv_nmos L=0.45u W=0.15u AS=0.1005p
+ AD=0.0555p PS=1.34u PD=0.74u rfmode=0
M$3432 WBL[5] WWL[27] \$2282 GND sg13_hv_nmos L=0.45u W=0.15u AS=0.0555p
+ AD=0.1005p PS=0.74u PD=1.34u rfmode=0
M$3433 \$2205 WWL[26] WBL[6] GND sg13_hv_nmos L=0.45u W=0.15u AS=0.1005p
+ AD=0.0555p PS=1.34u PD=0.74u rfmode=0
M$3434 WBL[6] WWL[27] \$2283 GND sg13_hv_nmos L=0.45u W=0.15u AS=0.0555p
+ AD=0.1005p PS=0.74u PD=1.34u rfmode=0
M$3435 \$2206 WWL[26] WBL[7] GND sg13_hv_nmos L=0.45u W=0.15u AS=0.1005p
+ AD=0.0555p PS=1.34u PD=0.74u rfmode=0
M$3436 WBL[7] WWL[27] \$2284 GND sg13_hv_nmos L=0.45u W=0.15u AS=0.0555p
+ AD=0.1005p PS=0.74u PD=1.34u rfmode=0
M$3437 \$2207 WWL[26] WBL[8] GND sg13_hv_nmos L=0.45u W=0.15u AS=0.1005p
+ AD=0.0555p PS=1.34u PD=0.74u rfmode=0
M$3438 WBL[8] WWL[27] \$2285 GND sg13_hv_nmos L=0.45u W=0.15u AS=0.0555p
+ AD=0.1005p PS=0.74u PD=1.34u rfmode=0
M$3439 \$2208 WWL[26] WBL[9] GND sg13_hv_nmos L=0.45u W=0.15u AS=0.1005p
+ AD=0.0555p PS=1.34u PD=0.74u rfmode=0
M$3440 WBL[9] WWL[27] \$2286 GND sg13_hv_nmos L=0.45u W=0.15u AS=0.0555p
+ AD=0.1005p PS=0.74u PD=1.34u rfmode=0
M$3441 \$2209 WWL[26] WBL[10] GND sg13_hv_nmos L=0.45u W=0.15u AS=0.1005p
+ AD=0.0555p PS=1.34u PD=0.74u rfmode=0
M$3442 WBL[10] WWL[27] \$2287 GND sg13_hv_nmos L=0.45u W=0.15u AS=0.0555p
+ AD=0.1005p PS=0.74u PD=1.34u rfmode=0
M$3443 \$2210 WWL[26] WBL[11] GND sg13_hv_nmos L=0.45u W=0.15u AS=0.1005p
+ AD=0.0555p PS=1.34u PD=0.74u rfmode=0
M$3444 WBL[11] WWL[27] \$2288 GND sg13_hv_nmos L=0.45u W=0.15u AS=0.0555p
+ AD=0.1005p PS=0.74u PD=1.34u rfmode=0
M$3445 \$2211 WWL[26] WBL[12] GND sg13_hv_nmos L=0.45u W=0.15u AS=0.1005p
+ AD=0.0555p PS=1.34u PD=0.74u rfmode=0
M$3446 WBL[12] WWL[27] \$2289 GND sg13_hv_nmos L=0.45u W=0.15u AS=0.0555p
+ AD=0.1005p PS=0.74u PD=1.34u rfmode=0
M$3447 \$2212 WWL[26] WBL[13] GND sg13_hv_nmos L=0.45u W=0.15u AS=0.1005p
+ AD=0.0555p PS=1.34u PD=0.74u rfmode=0
M$3448 WBL[13] WWL[27] \$2290 GND sg13_hv_nmos L=0.45u W=0.15u AS=0.0555p
+ AD=0.1005p PS=0.74u PD=1.34u rfmode=0
M$3449 \$2213 WWL[26] WBL[14] GND sg13_hv_nmos L=0.45u W=0.15u AS=0.1005p
+ AD=0.0555p PS=1.34u PD=0.74u rfmode=0
M$3450 WBL[14] WWL[27] \$2291 GND sg13_hv_nmos L=0.45u W=0.15u AS=0.0555p
+ AD=0.1005p PS=0.74u PD=1.34u rfmode=0
M$3451 \$2214 WWL[26] WBL[15] GND sg13_hv_nmos L=0.45u W=0.15u AS=0.1005p
+ AD=0.0555p PS=1.34u PD=0.74u rfmode=0
M$3452 WBL[15] WWL[27] \$2292 GND sg13_hv_nmos L=0.45u W=0.15u AS=0.0555p
+ AD=0.1005p PS=0.74u PD=1.34u rfmode=0
M$3453 \$2215 WWL[26] WBL[16] GND sg13_hv_nmos L=0.45u W=0.15u AS=0.1005p
+ AD=0.0555p PS=1.34u PD=0.74u rfmode=0
M$3454 WBL[16] WWL[27] \$2293 GND sg13_hv_nmos L=0.45u W=0.15u AS=0.0555p
+ AD=0.1005p PS=0.74u PD=1.34u rfmode=0
M$3455 \$2216 WWL[26] WBL[17] GND sg13_hv_nmos L=0.45u W=0.15u AS=0.1005p
+ AD=0.0555p PS=1.34u PD=0.74u rfmode=0
M$3456 WBL[17] WWL[27] \$2294 GND sg13_hv_nmos L=0.45u W=0.15u AS=0.0555p
+ AD=0.1005p PS=0.74u PD=1.34u rfmode=0
M$3457 \$2217 WWL[26] WBL[18] GND sg13_hv_nmos L=0.45u W=0.15u AS=0.1005p
+ AD=0.0555p PS=1.34u PD=0.74u rfmode=0
M$3458 WBL[18] WWL[27] \$2295 GND sg13_hv_nmos L=0.45u W=0.15u AS=0.0555p
+ AD=0.1005p PS=0.74u PD=1.34u rfmode=0
M$3459 \$2218 WWL[26] WBL[19] GND sg13_hv_nmos L=0.45u W=0.15u AS=0.1005p
+ AD=0.0555p PS=1.34u PD=0.74u rfmode=0
M$3460 WBL[19] WWL[27] \$2296 GND sg13_hv_nmos L=0.45u W=0.15u AS=0.0555p
+ AD=0.1005p PS=0.74u PD=1.34u rfmode=0
M$3461 \$2219 WWL[26] WBL[20] GND sg13_hv_nmos L=0.45u W=0.15u AS=0.1005p
+ AD=0.0555p PS=1.34u PD=0.74u rfmode=0
M$3462 WBL[20] WWL[27] \$2297 GND sg13_hv_nmos L=0.45u W=0.15u AS=0.0555p
+ AD=0.1005p PS=0.74u PD=1.34u rfmode=0
M$3463 \$2220 WWL[26] WBL[21] GND sg13_hv_nmos L=0.45u W=0.15u AS=0.1005p
+ AD=0.0555p PS=1.34u PD=0.74u rfmode=0
M$3464 WBL[21] WWL[27] \$2298 GND sg13_hv_nmos L=0.45u W=0.15u AS=0.0555p
+ AD=0.1005p PS=0.74u PD=1.34u rfmode=0
M$3465 \$2221 WWL[26] WBL[22] GND sg13_hv_nmos L=0.45u W=0.15u AS=0.1005p
+ AD=0.0555p PS=1.34u PD=0.74u rfmode=0
M$3466 WBL[22] WWL[27] \$2299 GND sg13_hv_nmos L=0.45u W=0.15u AS=0.0555p
+ AD=0.1005p PS=0.74u PD=1.34u rfmode=0
M$3467 \$2222 WWL[26] WBL[23] GND sg13_hv_nmos L=0.45u W=0.15u AS=0.1005p
+ AD=0.0555p PS=1.34u PD=0.74u rfmode=0
M$3468 WBL[23] WWL[27] \$2300 GND sg13_hv_nmos L=0.45u W=0.15u AS=0.0555p
+ AD=0.1005p PS=0.74u PD=1.34u rfmode=0
M$3469 \$2223 WWL[26] WBL[24] GND sg13_hv_nmos L=0.45u W=0.15u AS=0.1005p
+ AD=0.0555p PS=1.34u PD=0.74u rfmode=0
M$3470 WBL[24] WWL[27] \$2301 GND sg13_hv_nmos L=0.45u W=0.15u AS=0.0555p
+ AD=0.1005p PS=0.74u PD=1.34u rfmode=0
M$3471 \$2224 WWL[26] WBL[25] GND sg13_hv_nmos L=0.45u W=0.15u AS=0.1005p
+ AD=0.0555p PS=1.34u PD=0.74u rfmode=0
M$3472 WBL[25] WWL[27] \$2302 GND sg13_hv_nmos L=0.45u W=0.15u AS=0.0555p
+ AD=0.1005p PS=0.74u PD=1.34u rfmode=0
M$3473 \$2225 WWL[26] WBL[26] GND sg13_hv_nmos L=0.45u W=0.15u AS=0.1005p
+ AD=0.0555p PS=1.34u PD=0.74u rfmode=0
M$3474 WBL[26] WWL[27] \$2303 GND sg13_hv_nmos L=0.45u W=0.15u AS=0.0555p
+ AD=0.1005p PS=0.74u PD=1.34u rfmode=0
M$3475 \$2226 WWL[26] WBL[27] GND sg13_hv_nmos L=0.45u W=0.15u AS=0.1005p
+ AD=0.0555p PS=1.34u PD=0.74u rfmode=0
M$3476 WBL[27] WWL[27] \$2304 GND sg13_hv_nmos L=0.45u W=0.15u AS=0.0555p
+ AD=0.1005p PS=0.74u PD=1.34u rfmode=0
M$3477 \$2227 WWL[26] WBL[28] GND sg13_hv_nmos L=0.45u W=0.15u AS=0.1005p
+ AD=0.0555p PS=1.34u PD=0.74u rfmode=0
M$3478 WBL[28] WWL[27] \$2305 GND sg13_hv_nmos L=0.45u W=0.15u AS=0.0555p
+ AD=0.1005p PS=0.74u PD=1.34u rfmode=0
M$3479 \$2228 WWL[26] WBL[29] GND sg13_hv_nmos L=0.45u W=0.15u AS=0.1005p
+ AD=0.0555p PS=1.34u PD=0.74u rfmode=0
M$3480 WBL[29] WWL[27] \$2306 GND sg13_hv_nmos L=0.45u W=0.15u AS=0.0555p
+ AD=0.1005p PS=0.74u PD=1.34u rfmode=0
M$3481 \$2229 WWL[26] WBL[30] GND sg13_hv_nmos L=0.45u W=0.15u AS=0.1005p
+ AD=0.0555p PS=1.34u PD=0.74u rfmode=0
M$3482 WBL[30] WWL[27] \$2307 GND sg13_hv_nmos L=0.45u W=0.15u AS=0.0555p
+ AD=0.1005p PS=0.74u PD=1.34u rfmode=0
M$3483 \$2230 WWL[26] WBL[31] GND sg13_hv_nmos L=0.45u W=0.15u AS=0.1005p
+ AD=0.0555p PS=1.34u PD=0.74u rfmode=0
M$3484 WBL[31] WWL[27] \$2308 GND sg13_hv_nmos L=0.45u W=0.15u AS=0.0555p
+ AD=0.1005p PS=0.74u PD=1.34u rfmode=0
M$3485 \$2231 WWL[26] WBL[32] GND sg13_hv_nmos L=0.45u W=0.15u AS=0.1005p
+ AD=0.0555p PS=1.34u PD=0.74u rfmode=0
M$3486 WBL[32] WWL[27] \$2309 GND sg13_hv_nmos L=0.45u W=0.15u AS=0.0555p
+ AD=0.1005p PS=0.74u PD=1.34u rfmode=0
M$3487 \$2232 WWL[26] WBL[33] GND sg13_hv_nmos L=0.45u W=0.15u AS=0.1005p
+ AD=0.0555p PS=1.34u PD=0.74u rfmode=0
M$3488 WBL[33] WWL[27] \$2310 GND sg13_hv_nmos L=0.45u W=0.15u AS=0.0555p
+ AD=0.1005p PS=0.74u PD=1.34u rfmode=0
M$3489 \$2233 WWL[26] WBL[34] GND sg13_hv_nmos L=0.45u W=0.15u AS=0.1005p
+ AD=0.0555p PS=1.34u PD=0.74u rfmode=0
M$3490 WBL[34] WWL[27] \$2311 GND sg13_hv_nmos L=0.45u W=0.15u AS=0.0555p
+ AD=0.1005p PS=0.74u PD=1.34u rfmode=0
M$3491 \$2234 WWL[26] WBL[35] GND sg13_hv_nmos L=0.45u W=0.15u AS=0.1005p
+ AD=0.0555p PS=1.34u PD=0.74u rfmode=0
M$3492 WBL[35] WWL[27] \$2312 GND sg13_hv_nmos L=0.45u W=0.15u AS=0.0555p
+ AD=0.1005p PS=0.74u PD=1.34u rfmode=0
M$3493 \$2235 WWL[26] WBL[36] GND sg13_hv_nmos L=0.45u W=0.15u AS=0.1005p
+ AD=0.0555p PS=1.34u PD=0.74u rfmode=0
M$3494 WBL[36] WWL[27] \$2313 GND sg13_hv_nmos L=0.45u W=0.15u AS=0.0555p
+ AD=0.1005p PS=0.74u PD=1.34u rfmode=0
M$3495 \$2236 WWL[26] WBL[37] GND sg13_hv_nmos L=0.45u W=0.15u AS=0.1005p
+ AD=0.0555p PS=1.34u PD=0.74u rfmode=0
M$3496 WBL[37] WWL[27] \$2314 GND sg13_hv_nmos L=0.45u W=0.15u AS=0.0555p
+ AD=0.1005p PS=0.74u PD=1.34u rfmode=0
M$3497 \$2362 WWL[28] WBL[0] GND sg13_hv_nmos L=0.45u W=0.15u AS=0.1005p
+ AD=0.0555p PS=1.34u PD=0.74u rfmode=0
M$3498 WBL[0] WWL[29] \$2440 GND sg13_hv_nmos L=0.45u W=0.15u AS=0.0555p
+ AD=0.1005p PS=0.74u PD=1.34u rfmode=0
M$3499 \$2363 WWL[28] WBL[1] GND sg13_hv_nmos L=0.45u W=0.15u AS=0.1005p
+ AD=0.0555p PS=1.34u PD=0.74u rfmode=0
M$3500 WBL[1] WWL[29] \$2441 GND sg13_hv_nmos L=0.45u W=0.15u AS=0.0555p
+ AD=0.1005p PS=0.74u PD=1.34u rfmode=0
M$3501 \$2364 WWL[28] WBL[2] GND sg13_hv_nmos L=0.45u W=0.15u AS=0.1005p
+ AD=0.0555p PS=1.34u PD=0.74u rfmode=0
M$3502 WBL[2] WWL[29] \$2442 GND sg13_hv_nmos L=0.45u W=0.15u AS=0.0555p
+ AD=0.1005p PS=0.74u PD=1.34u rfmode=0
M$3503 \$2365 WWL[28] WBL[3] GND sg13_hv_nmos L=0.45u W=0.15u AS=0.1005p
+ AD=0.0555p PS=1.34u PD=0.74u rfmode=0
M$3504 WBL[3] WWL[29] \$2443 GND sg13_hv_nmos L=0.45u W=0.15u AS=0.0555p
+ AD=0.1005p PS=0.74u PD=1.34u rfmode=0
M$3505 \$2366 WWL[28] WBL[4] GND sg13_hv_nmos L=0.45u W=0.15u AS=0.1005p
+ AD=0.0555p PS=1.34u PD=0.74u rfmode=0
M$3506 WBL[4] WWL[29] \$2444 GND sg13_hv_nmos L=0.45u W=0.15u AS=0.0555p
+ AD=0.1005p PS=0.74u PD=1.34u rfmode=0
M$3507 \$2367 WWL[28] WBL[5] GND sg13_hv_nmos L=0.45u W=0.15u AS=0.1005p
+ AD=0.0555p PS=1.34u PD=0.74u rfmode=0
M$3508 WBL[5] WWL[29] \$2445 GND sg13_hv_nmos L=0.45u W=0.15u AS=0.0555p
+ AD=0.1005p PS=0.74u PD=1.34u rfmode=0
M$3509 \$2368 WWL[28] WBL[6] GND sg13_hv_nmos L=0.45u W=0.15u AS=0.1005p
+ AD=0.0555p PS=1.34u PD=0.74u rfmode=0
M$3510 WBL[6] WWL[29] \$2446 GND sg13_hv_nmos L=0.45u W=0.15u AS=0.0555p
+ AD=0.1005p PS=0.74u PD=1.34u rfmode=0
M$3511 \$2369 WWL[28] WBL[7] GND sg13_hv_nmos L=0.45u W=0.15u AS=0.1005p
+ AD=0.0555p PS=1.34u PD=0.74u rfmode=0
M$3512 WBL[7] WWL[29] \$2447 GND sg13_hv_nmos L=0.45u W=0.15u AS=0.0555p
+ AD=0.1005p PS=0.74u PD=1.34u rfmode=0
M$3513 \$2370 WWL[28] WBL[8] GND sg13_hv_nmos L=0.45u W=0.15u AS=0.1005p
+ AD=0.0555p PS=1.34u PD=0.74u rfmode=0
M$3514 WBL[8] WWL[29] \$2448 GND sg13_hv_nmos L=0.45u W=0.15u AS=0.0555p
+ AD=0.1005p PS=0.74u PD=1.34u rfmode=0
M$3515 \$2371 WWL[28] WBL[9] GND sg13_hv_nmos L=0.45u W=0.15u AS=0.1005p
+ AD=0.0555p PS=1.34u PD=0.74u rfmode=0
M$3516 WBL[9] WWL[29] \$2449 GND sg13_hv_nmos L=0.45u W=0.15u AS=0.0555p
+ AD=0.1005p PS=0.74u PD=1.34u rfmode=0
M$3517 \$2372 WWL[28] WBL[10] GND sg13_hv_nmos L=0.45u W=0.15u AS=0.1005p
+ AD=0.0555p PS=1.34u PD=0.74u rfmode=0
M$3518 WBL[10] WWL[29] \$2450 GND sg13_hv_nmos L=0.45u W=0.15u AS=0.0555p
+ AD=0.1005p PS=0.74u PD=1.34u rfmode=0
M$3519 \$2373 WWL[28] WBL[11] GND sg13_hv_nmos L=0.45u W=0.15u AS=0.1005p
+ AD=0.0555p PS=1.34u PD=0.74u rfmode=0
M$3520 WBL[11] WWL[29] \$2451 GND sg13_hv_nmos L=0.45u W=0.15u AS=0.0555p
+ AD=0.1005p PS=0.74u PD=1.34u rfmode=0
M$3521 \$2374 WWL[28] WBL[12] GND sg13_hv_nmos L=0.45u W=0.15u AS=0.1005p
+ AD=0.0555p PS=1.34u PD=0.74u rfmode=0
M$3522 WBL[12] WWL[29] \$2452 GND sg13_hv_nmos L=0.45u W=0.15u AS=0.0555p
+ AD=0.1005p PS=0.74u PD=1.34u rfmode=0
M$3523 \$2375 WWL[28] WBL[13] GND sg13_hv_nmos L=0.45u W=0.15u AS=0.1005p
+ AD=0.0555p PS=1.34u PD=0.74u rfmode=0
M$3524 WBL[13] WWL[29] \$2453 GND sg13_hv_nmos L=0.45u W=0.15u AS=0.0555p
+ AD=0.1005p PS=0.74u PD=1.34u rfmode=0
M$3525 \$2376 WWL[28] WBL[14] GND sg13_hv_nmos L=0.45u W=0.15u AS=0.1005p
+ AD=0.0555p PS=1.34u PD=0.74u rfmode=0
M$3526 WBL[14] WWL[29] \$2454 GND sg13_hv_nmos L=0.45u W=0.15u AS=0.0555p
+ AD=0.1005p PS=0.74u PD=1.34u rfmode=0
M$3527 \$2377 WWL[28] WBL[15] GND sg13_hv_nmos L=0.45u W=0.15u AS=0.1005p
+ AD=0.0555p PS=1.34u PD=0.74u rfmode=0
M$3528 WBL[15] WWL[29] \$2455 GND sg13_hv_nmos L=0.45u W=0.15u AS=0.0555p
+ AD=0.1005p PS=0.74u PD=1.34u rfmode=0
M$3529 \$2378 WWL[28] WBL[16] GND sg13_hv_nmos L=0.45u W=0.15u AS=0.1005p
+ AD=0.0555p PS=1.34u PD=0.74u rfmode=0
M$3530 WBL[16] WWL[29] \$2456 GND sg13_hv_nmos L=0.45u W=0.15u AS=0.0555p
+ AD=0.1005p PS=0.74u PD=1.34u rfmode=0
M$3531 \$2379 WWL[28] WBL[17] GND sg13_hv_nmos L=0.45u W=0.15u AS=0.1005p
+ AD=0.0555p PS=1.34u PD=0.74u rfmode=0
M$3532 WBL[17] WWL[29] \$2457 GND sg13_hv_nmos L=0.45u W=0.15u AS=0.0555p
+ AD=0.1005p PS=0.74u PD=1.34u rfmode=0
M$3533 \$2380 WWL[28] WBL[18] GND sg13_hv_nmos L=0.45u W=0.15u AS=0.1005p
+ AD=0.0555p PS=1.34u PD=0.74u rfmode=0
M$3534 WBL[18] WWL[29] \$2458 GND sg13_hv_nmos L=0.45u W=0.15u AS=0.0555p
+ AD=0.1005p PS=0.74u PD=1.34u rfmode=0
M$3535 \$2381 WWL[28] WBL[19] GND sg13_hv_nmos L=0.45u W=0.15u AS=0.1005p
+ AD=0.0555p PS=1.34u PD=0.74u rfmode=0
M$3536 WBL[19] WWL[29] \$2459 GND sg13_hv_nmos L=0.45u W=0.15u AS=0.0555p
+ AD=0.1005p PS=0.74u PD=1.34u rfmode=0
M$3537 \$2382 WWL[28] WBL[20] GND sg13_hv_nmos L=0.45u W=0.15u AS=0.1005p
+ AD=0.0555p PS=1.34u PD=0.74u rfmode=0
M$3538 WBL[20] WWL[29] \$2460 GND sg13_hv_nmos L=0.45u W=0.15u AS=0.0555p
+ AD=0.1005p PS=0.74u PD=1.34u rfmode=0
M$3539 \$2383 WWL[28] WBL[21] GND sg13_hv_nmos L=0.45u W=0.15u AS=0.1005p
+ AD=0.0555p PS=1.34u PD=0.74u rfmode=0
M$3540 WBL[21] WWL[29] \$2461 GND sg13_hv_nmos L=0.45u W=0.15u AS=0.0555p
+ AD=0.1005p PS=0.74u PD=1.34u rfmode=0
M$3541 \$2384 WWL[28] WBL[22] GND sg13_hv_nmos L=0.45u W=0.15u AS=0.1005p
+ AD=0.0555p PS=1.34u PD=0.74u rfmode=0
M$3542 WBL[22] WWL[29] \$2462 GND sg13_hv_nmos L=0.45u W=0.15u AS=0.0555p
+ AD=0.1005p PS=0.74u PD=1.34u rfmode=0
M$3543 \$2385 WWL[28] WBL[23] GND sg13_hv_nmos L=0.45u W=0.15u AS=0.1005p
+ AD=0.0555p PS=1.34u PD=0.74u rfmode=0
M$3544 WBL[23] WWL[29] \$2463 GND sg13_hv_nmos L=0.45u W=0.15u AS=0.0555p
+ AD=0.1005p PS=0.74u PD=1.34u rfmode=0
M$3545 \$2386 WWL[28] WBL[24] GND sg13_hv_nmos L=0.45u W=0.15u AS=0.1005p
+ AD=0.0555p PS=1.34u PD=0.74u rfmode=0
M$3546 WBL[24] WWL[29] \$2464 GND sg13_hv_nmos L=0.45u W=0.15u AS=0.0555p
+ AD=0.1005p PS=0.74u PD=1.34u rfmode=0
M$3547 \$2387 WWL[28] WBL[25] GND sg13_hv_nmos L=0.45u W=0.15u AS=0.1005p
+ AD=0.0555p PS=1.34u PD=0.74u rfmode=0
M$3548 WBL[25] WWL[29] \$2465 GND sg13_hv_nmos L=0.45u W=0.15u AS=0.0555p
+ AD=0.1005p PS=0.74u PD=1.34u rfmode=0
M$3549 \$2388 WWL[28] WBL[26] GND sg13_hv_nmos L=0.45u W=0.15u AS=0.1005p
+ AD=0.0555p PS=1.34u PD=0.74u rfmode=0
M$3550 WBL[26] WWL[29] \$2466 GND sg13_hv_nmos L=0.45u W=0.15u AS=0.0555p
+ AD=0.1005p PS=0.74u PD=1.34u rfmode=0
M$3551 \$2389 WWL[28] WBL[27] GND sg13_hv_nmos L=0.45u W=0.15u AS=0.1005p
+ AD=0.0555p PS=1.34u PD=0.74u rfmode=0
M$3552 WBL[27] WWL[29] \$2467 GND sg13_hv_nmos L=0.45u W=0.15u AS=0.0555p
+ AD=0.1005p PS=0.74u PD=1.34u rfmode=0
M$3553 \$2390 WWL[28] WBL[28] GND sg13_hv_nmos L=0.45u W=0.15u AS=0.1005p
+ AD=0.0555p PS=1.34u PD=0.74u rfmode=0
M$3554 WBL[28] WWL[29] \$2468 GND sg13_hv_nmos L=0.45u W=0.15u AS=0.0555p
+ AD=0.1005p PS=0.74u PD=1.34u rfmode=0
M$3555 \$2391 WWL[28] WBL[29] GND sg13_hv_nmos L=0.45u W=0.15u AS=0.1005p
+ AD=0.0555p PS=1.34u PD=0.74u rfmode=0
M$3556 WBL[29] WWL[29] \$2469 GND sg13_hv_nmos L=0.45u W=0.15u AS=0.0555p
+ AD=0.1005p PS=0.74u PD=1.34u rfmode=0
M$3557 \$2392 WWL[28] WBL[30] GND sg13_hv_nmos L=0.45u W=0.15u AS=0.1005p
+ AD=0.0555p PS=1.34u PD=0.74u rfmode=0
M$3558 WBL[30] WWL[29] \$2470 GND sg13_hv_nmos L=0.45u W=0.15u AS=0.0555p
+ AD=0.1005p PS=0.74u PD=1.34u rfmode=0
M$3559 \$2393 WWL[28] WBL[31] GND sg13_hv_nmos L=0.45u W=0.15u AS=0.1005p
+ AD=0.0555p PS=1.34u PD=0.74u rfmode=0
M$3560 WBL[31] WWL[29] \$2471 GND sg13_hv_nmos L=0.45u W=0.15u AS=0.0555p
+ AD=0.1005p PS=0.74u PD=1.34u rfmode=0
M$3561 \$2394 WWL[28] WBL[32] GND sg13_hv_nmos L=0.45u W=0.15u AS=0.1005p
+ AD=0.0555p PS=1.34u PD=0.74u rfmode=0
M$3562 WBL[32] WWL[29] \$2472 GND sg13_hv_nmos L=0.45u W=0.15u AS=0.0555p
+ AD=0.1005p PS=0.74u PD=1.34u rfmode=0
M$3563 \$2395 WWL[28] WBL[33] GND sg13_hv_nmos L=0.45u W=0.15u AS=0.1005p
+ AD=0.0555p PS=1.34u PD=0.74u rfmode=0
M$3564 WBL[33] WWL[29] \$2473 GND sg13_hv_nmos L=0.45u W=0.15u AS=0.0555p
+ AD=0.1005p PS=0.74u PD=1.34u rfmode=0
M$3565 \$2396 WWL[28] WBL[34] GND sg13_hv_nmos L=0.45u W=0.15u AS=0.1005p
+ AD=0.0555p PS=1.34u PD=0.74u rfmode=0
M$3566 WBL[34] WWL[29] \$2474 GND sg13_hv_nmos L=0.45u W=0.15u AS=0.0555p
+ AD=0.1005p PS=0.74u PD=1.34u rfmode=0
M$3567 \$2397 WWL[28] WBL[35] GND sg13_hv_nmos L=0.45u W=0.15u AS=0.1005p
+ AD=0.0555p PS=1.34u PD=0.74u rfmode=0
M$3568 WBL[35] WWL[29] \$2475 GND sg13_hv_nmos L=0.45u W=0.15u AS=0.0555p
+ AD=0.1005p PS=0.74u PD=1.34u rfmode=0
M$3569 \$2398 WWL[28] WBL[36] GND sg13_hv_nmos L=0.45u W=0.15u AS=0.1005p
+ AD=0.0555p PS=1.34u PD=0.74u rfmode=0
M$3570 WBL[36] WWL[29] \$2476 GND sg13_hv_nmos L=0.45u W=0.15u AS=0.0555p
+ AD=0.1005p PS=0.74u PD=1.34u rfmode=0
M$3571 \$2399 WWL[28] WBL[37] GND sg13_hv_nmos L=0.45u W=0.15u AS=0.1005p
+ AD=0.0555p PS=1.34u PD=0.74u rfmode=0
M$3572 WBL[37] WWL[29] \$2477 GND sg13_hv_nmos L=0.45u W=0.15u AS=0.0555p
+ AD=0.1005p PS=0.74u PD=1.34u rfmode=0
M$3573 \$2525 WWL[30] WBL[0] GND sg13_hv_nmos L=0.45u W=0.15u AS=0.1005p
+ AD=0.0555p PS=1.34u PD=0.74u rfmode=0
M$3574 WBL[0] WWL[31] \$2603 GND sg13_hv_nmos L=0.45u W=0.15u AS=0.0555p
+ AD=0.1005p PS=0.74u PD=1.34u rfmode=0
M$3575 \$2526 WWL[30] WBL[1] GND sg13_hv_nmos L=0.45u W=0.15u AS=0.1005p
+ AD=0.0555p PS=1.34u PD=0.74u rfmode=0
M$3576 WBL[1] WWL[31] \$2604 GND sg13_hv_nmos L=0.45u W=0.15u AS=0.0555p
+ AD=0.1005p PS=0.74u PD=1.34u rfmode=0
M$3577 \$2527 WWL[30] WBL[2] GND sg13_hv_nmos L=0.45u W=0.15u AS=0.1005p
+ AD=0.0555p PS=1.34u PD=0.74u rfmode=0
M$3578 WBL[2] WWL[31] \$2605 GND sg13_hv_nmos L=0.45u W=0.15u AS=0.0555p
+ AD=0.1005p PS=0.74u PD=1.34u rfmode=0
M$3579 \$2528 WWL[30] WBL[3] GND sg13_hv_nmos L=0.45u W=0.15u AS=0.1005p
+ AD=0.0555p PS=1.34u PD=0.74u rfmode=0
M$3580 WBL[3] WWL[31] \$2606 GND sg13_hv_nmos L=0.45u W=0.15u AS=0.0555p
+ AD=0.1005p PS=0.74u PD=1.34u rfmode=0
M$3581 \$2529 WWL[30] WBL[4] GND sg13_hv_nmos L=0.45u W=0.15u AS=0.1005p
+ AD=0.0555p PS=1.34u PD=0.74u rfmode=0
M$3582 WBL[4] WWL[31] \$2607 GND sg13_hv_nmos L=0.45u W=0.15u AS=0.0555p
+ AD=0.1005p PS=0.74u PD=1.34u rfmode=0
M$3583 \$2530 WWL[30] WBL[5] GND sg13_hv_nmos L=0.45u W=0.15u AS=0.1005p
+ AD=0.0555p PS=1.34u PD=0.74u rfmode=0
M$3584 WBL[5] WWL[31] \$2608 GND sg13_hv_nmos L=0.45u W=0.15u AS=0.0555p
+ AD=0.1005p PS=0.74u PD=1.34u rfmode=0
M$3585 \$2531 WWL[30] WBL[6] GND sg13_hv_nmos L=0.45u W=0.15u AS=0.1005p
+ AD=0.0555p PS=1.34u PD=0.74u rfmode=0
M$3586 WBL[6] WWL[31] \$2609 GND sg13_hv_nmos L=0.45u W=0.15u AS=0.0555p
+ AD=0.1005p PS=0.74u PD=1.34u rfmode=0
M$3587 \$2532 WWL[30] WBL[7] GND sg13_hv_nmos L=0.45u W=0.15u AS=0.1005p
+ AD=0.0555p PS=1.34u PD=0.74u rfmode=0
M$3588 WBL[7] WWL[31] \$2610 GND sg13_hv_nmos L=0.45u W=0.15u AS=0.0555p
+ AD=0.1005p PS=0.74u PD=1.34u rfmode=0
M$3589 \$2533 WWL[30] WBL[8] GND sg13_hv_nmos L=0.45u W=0.15u AS=0.1005p
+ AD=0.0555p PS=1.34u PD=0.74u rfmode=0
M$3590 WBL[8] WWL[31] \$2611 GND sg13_hv_nmos L=0.45u W=0.15u AS=0.0555p
+ AD=0.1005p PS=0.74u PD=1.34u rfmode=0
M$3591 \$2534 WWL[30] WBL[9] GND sg13_hv_nmos L=0.45u W=0.15u AS=0.1005p
+ AD=0.0555p PS=1.34u PD=0.74u rfmode=0
M$3592 WBL[9] WWL[31] \$2612 GND sg13_hv_nmos L=0.45u W=0.15u AS=0.0555p
+ AD=0.1005p PS=0.74u PD=1.34u rfmode=0
M$3593 \$2535 WWL[30] WBL[10] GND sg13_hv_nmos L=0.45u W=0.15u AS=0.1005p
+ AD=0.0555p PS=1.34u PD=0.74u rfmode=0
M$3594 WBL[10] WWL[31] \$2613 GND sg13_hv_nmos L=0.45u W=0.15u AS=0.0555p
+ AD=0.1005p PS=0.74u PD=1.34u rfmode=0
M$3595 \$2536 WWL[30] WBL[11] GND sg13_hv_nmos L=0.45u W=0.15u AS=0.1005p
+ AD=0.0555p PS=1.34u PD=0.74u rfmode=0
M$3596 WBL[11] WWL[31] \$2614 GND sg13_hv_nmos L=0.45u W=0.15u AS=0.0555p
+ AD=0.1005p PS=0.74u PD=1.34u rfmode=0
M$3597 \$2537 WWL[30] WBL[12] GND sg13_hv_nmos L=0.45u W=0.15u AS=0.1005p
+ AD=0.0555p PS=1.34u PD=0.74u rfmode=0
M$3598 WBL[12] WWL[31] \$2615 GND sg13_hv_nmos L=0.45u W=0.15u AS=0.0555p
+ AD=0.1005p PS=0.74u PD=1.34u rfmode=0
M$3599 \$2538 WWL[30] WBL[13] GND sg13_hv_nmos L=0.45u W=0.15u AS=0.1005p
+ AD=0.0555p PS=1.34u PD=0.74u rfmode=0
M$3600 WBL[13] WWL[31] \$2616 GND sg13_hv_nmos L=0.45u W=0.15u AS=0.0555p
+ AD=0.1005p PS=0.74u PD=1.34u rfmode=0
M$3601 \$2539 WWL[30] WBL[14] GND sg13_hv_nmos L=0.45u W=0.15u AS=0.1005p
+ AD=0.0555p PS=1.34u PD=0.74u rfmode=0
M$3602 WBL[14] WWL[31] \$2617 GND sg13_hv_nmos L=0.45u W=0.15u AS=0.0555p
+ AD=0.1005p PS=0.74u PD=1.34u rfmode=0
M$3603 \$2540 WWL[30] WBL[15] GND sg13_hv_nmos L=0.45u W=0.15u AS=0.1005p
+ AD=0.0555p PS=1.34u PD=0.74u rfmode=0
M$3604 WBL[15] WWL[31] \$2618 GND sg13_hv_nmos L=0.45u W=0.15u AS=0.0555p
+ AD=0.1005p PS=0.74u PD=1.34u rfmode=0
M$3605 \$2541 WWL[30] WBL[16] GND sg13_hv_nmos L=0.45u W=0.15u AS=0.1005p
+ AD=0.0555p PS=1.34u PD=0.74u rfmode=0
M$3606 WBL[16] WWL[31] \$2619 GND sg13_hv_nmos L=0.45u W=0.15u AS=0.0555p
+ AD=0.1005p PS=0.74u PD=1.34u rfmode=0
M$3607 \$2542 WWL[30] WBL[17] GND sg13_hv_nmos L=0.45u W=0.15u AS=0.1005p
+ AD=0.0555p PS=1.34u PD=0.74u rfmode=0
M$3608 WBL[17] WWL[31] \$2620 GND sg13_hv_nmos L=0.45u W=0.15u AS=0.0555p
+ AD=0.1005p PS=0.74u PD=1.34u rfmode=0
M$3609 \$2543 WWL[30] WBL[18] GND sg13_hv_nmos L=0.45u W=0.15u AS=0.1005p
+ AD=0.0555p PS=1.34u PD=0.74u rfmode=0
M$3610 WBL[18] WWL[31] \$2621 GND sg13_hv_nmos L=0.45u W=0.15u AS=0.0555p
+ AD=0.1005p PS=0.74u PD=1.34u rfmode=0
M$3611 \$2544 WWL[30] WBL[19] GND sg13_hv_nmos L=0.45u W=0.15u AS=0.1005p
+ AD=0.0555p PS=1.34u PD=0.74u rfmode=0
M$3612 WBL[19] WWL[31] \$2622 GND sg13_hv_nmos L=0.45u W=0.15u AS=0.0555p
+ AD=0.1005p PS=0.74u PD=1.34u rfmode=0
M$3613 \$2545 WWL[30] WBL[20] GND sg13_hv_nmos L=0.45u W=0.15u AS=0.1005p
+ AD=0.0555p PS=1.34u PD=0.74u rfmode=0
M$3614 WBL[20] WWL[31] \$2623 GND sg13_hv_nmos L=0.45u W=0.15u AS=0.0555p
+ AD=0.1005p PS=0.74u PD=1.34u rfmode=0
M$3615 \$2546 WWL[30] WBL[21] GND sg13_hv_nmos L=0.45u W=0.15u AS=0.1005p
+ AD=0.0555p PS=1.34u PD=0.74u rfmode=0
M$3616 WBL[21] WWL[31] \$2624 GND sg13_hv_nmos L=0.45u W=0.15u AS=0.0555p
+ AD=0.1005p PS=0.74u PD=1.34u rfmode=0
M$3617 \$2547 WWL[30] WBL[22] GND sg13_hv_nmos L=0.45u W=0.15u AS=0.1005p
+ AD=0.0555p PS=1.34u PD=0.74u rfmode=0
M$3618 WBL[22] WWL[31] \$2625 GND sg13_hv_nmos L=0.45u W=0.15u AS=0.0555p
+ AD=0.1005p PS=0.74u PD=1.34u rfmode=0
M$3619 \$2548 WWL[30] WBL[23] GND sg13_hv_nmos L=0.45u W=0.15u AS=0.1005p
+ AD=0.0555p PS=1.34u PD=0.74u rfmode=0
M$3620 WBL[23] WWL[31] \$2626 GND sg13_hv_nmos L=0.45u W=0.15u AS=0.0555p
+ AD=0.1005p PS=0.74u PD=1.34u rfmode=0
M$3621 \$2549 WWL[30] WBL[24] GND sg13_hv_nmos L=0.45u W=0.15u AS=0.1005p
+ AD=0.0555p PS=1.34u PD=0.74u rfmode=0
M$3622 WBL[24] WWL[31] \$2627 GND sg13_hv_nmos L=0.45u W=0.15u AS=0.0555p
+ AD=0.1005p PS=0.74u PD=1.34u rfmode=0
M$3623 \$2550 WWL[30] WBL[25] GND sg13_hv_nmos L=0.45u W=0.15u AS=0.1005p
+ AD=0.0555p PS=1.34u PD=0.74u rfmode=0
M$3624 WBL[25] WWL[31] \$2628 GND sg13_hv_nmos L=0.45u W=0.15u AS=0.0555p
+ AD=0.1005p PS=0.74u PD=1.34u rfmode=0
M$3625 \$2551 WWL[30] WBL[26] GND sg13_hv_nmos L=0.45u W=0.15u AS=0.1005p
+ AD=0.0555p PS=1.34u PD=0.74u rfmode=0
M$3626 WBL[26] WWL[31] \$2629 GND sg13_hv_nmos L=0.45u W=0.15u AS=0.0555p
+ AD=0.1005p PS=0.74u PD=1.34u rfmode=0
M$3627 \$2552 WWL[30] WBL[27] GND sg13_hv_nmos L=0.45u W=0.15u AS=0.1005p
+ AD=0.0555p PS=1.34u PD=0.74u rfmode=0
M$3628 WBL[27] WWL[31] \$2630 GND sg13_hv_nmos L=0.45u W=0.15u AS=0.0555p
+ AD=0.1005p PS=0.74u PD=1.34u rfmode=0
M$3629 \$2553 WWL[30] WBL[28] GND sg13_hv_nmos L=0.45u W=0.15u AS=0.1005p
+ AD=0.0555p PS=1.34u PD=0.74u rfmode=0
M$3630 WBL[28] WWL[31] \$2631 GND sg13_hv_nmos L=0.45u W=0.15u AS=0.0555p
+ AD=0.1005p PS=0.74u PD=1.34u rfmode=0
M$3631 \$2554 WWL[30] WBL[29] GND sg13_hv_nmos L=0.45u W=0.15u AS=0.1005p
+ AD=0.0555p PS=1.34u PD=0.74u rfmode=0
M$3632 WBL[29] WWL[31] \$2632 GND sg13_hv_nmos L=0.45u W=0.15u AS=0.0555p
+ AD=0.1005p PS=0.74u PD=1.34u rfmode=0
M$3633 \$2555 WWL[30] WBL[30] GND sg13_hv_nmos L=0.45u W=0.15u AS=0.1005p
+ AD=0.0555p PS=1.34u PD=0.74u rfmode=0
M$3634 WBL[30] WWL[31] \$2633 GND sg13_hv_nmos L=0.45u W=0.15u AS=0.0555p
+ AD=0.1005p PS=0.74u PD=1.34u rfmode=0
M$3635 \$2556 WWL[30] WBL[31] GND sg13_hv_nmos L=0.45u W=0.15u AS=0.1005p
+ AD=0.0555p PS=1.34u PD=0.74u rfmode=0
M$3636 WBL[31] WWL[31] \$2634 GND sg13_hv_nmos L=0.45u W=0.15u AS=0.0555p
+ AD=0.1005p PS=0.74u PD=1.34u rfmode=0
M$3637 \$2557 WWL[30] WBL[32] GND sg13_hv_nmos L=0.45u W=0.15u AS=0.1005p
+ AD=0.0555p PS=1.34u PD=0.74u rfmode=0
M$3638 WBL[32] WWL[31] \$2635 GND sg13_hv_nmos L=0.45u W=0.15u AS=0.0555p
+ AD=0.1005p PS=0.74u PD=1.34u rfmode=0
M$3639 \$2558 WWL[30] WBL[33] GND sg13_hv_nmos L=0.45u W=0.15u AS=0.1005p
+ AD=0.0555p PS=1.34u PD=0.74u rfmode=0
M$3640 WBL[33] WWL[31] \$2636 GND sg13_hv_nmos L=0.45u W=0.15u AS=0.0555p
+ AD=0.1005p PS=0.74u PD=1.34u rfmode=0
M$3641 \$2559 WWL[30] WBL[34] GND sg13_hv_nmos L=0.45u W=0.15u AS=0.1005p
+ AD=0.0555p PS=1.34u PD=0.74u rfmode=0
M$3642 WBL[34] WWL[31] \$2637 GND sg13_hv_nmos L=0.45u W=0.15u AS=0.0555p
+ AD=0.1005p PS=0.74u PD=1.34u rfmode=0
M$3643 \$2560 WWL[30] WBL[35] GND sg13_hv_nmos L=0.45u W=0.15u AS=0.1005p
+ AD=0.0555p PS=1.34u PD=0.74u rfmode=0
M$3644 WBL[35] WWL[31] \$2638 GND sg13_hv_nmos L=0.45u W=0.15u AS=0.0555p
+ AD=0.1005p PS=0.74u PD=1.34u rfmode=0
M$3645 \$2561 WWL[30] WBL[36] GND sg13_hv_nmos L=0.45u W=0.15u AS=0.1005p
+ AD=0.0555p PS=1.34u PD=0.74u rfmode=0
M$3646 WBL[36] WWL[31] \$2639 GND sg13_hv_nmos L=0.45u W=0.15u AS=0.0555p
+ AD=0.1005p PS=0.74u PD=1.34u rfmode=0
M$3647 \$2562 WWL[30] WBL[37] GND sg13_hv_nmos L=0.45u W=0.15u AS=0.1005p
+ AD=0.0555p PS=1.34u PD=0.74u rfmode=0
M$3648 WBL[37] WWL[31] \$2640 GND sg13_hv_nmos L=0.45u W=0.15u AS=0.0555p
+ AD=0.1005p PS=0.74u PD=1.34u rfmode=0
.ENDS GC_ARRAY_32x38
