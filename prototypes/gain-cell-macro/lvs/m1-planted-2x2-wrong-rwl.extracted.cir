* Extracted by KLayout with SG13CMOS5L LVS runset on : 06/10/2026 00:19

.SUBCKT GC_ARRAY_2x2 GND RBL[0] RBL[1] RWL[0] RWL[1] WBL[0] WBL[1] WWL[0] WWL[1]
M$1 RBL[0] RWL[0] \$8 GND sg13_lv_nmos L=0.13u W=0.3u AS=0.102p AD=0.0525p
+ PS=1.28u PD=0.65u rfmode=0
M$2 RBL[1] RWL[0] \$9 GND sg13_lv_nmos L=0.13u W=0.3u AS=0.102p AD=0.0525p
+ PS=1.28u PD=0.65u rfmode=0
M$3 \$8 \$5 GND GND sg13_lv_nmos L=0.13u W=0.3u AS=0.0525p AD=0.3465p PS=0.65u
+ PD=2.61u rfmode=0
M$4 \$9 \$6 GND GND sg13_lv_nmos L=0.13u W=0.3u AS=0.0525p AD=0.3465p PS=0.65u
+ PD=2.61u rfmode=0
M$5 GND \$14 \$22 GND sg13_lv_nmos L=0.13u W=0.3u AS=0.3465p AD=0.0525p
+ PS=2.61u PD=0.65u rfmode=0
M$6 GND \$15 \$21 GND sg13_lv_nmos L=0.13u W=0.3u AS=0.3465p AD=0.0525p
+ PS=2.61u PD=0.65u rfmode=0
M$7 \$22 RWL[1] RBL[0] GND sg13_lv_nmos L=0.13u W=0.3u AS=0.0525p AD=0.102p
+ PS=0.65u PD=1.28u rfmode=0
M$8 \$21 RWL[1] RBL[1] GND sg13_lv_nmos L=0.13u W=0.3u AS=0.0525p AD=0.102p
+ PS=0.65u PD=1.28u rfmode=0
M$9 \$5 WWL[0] WBL[0] GND sg13_hv_nmos L=0.45u W=0.15u AS=0.1005p AD=0.0555p
+ PS=1.34u PD=0.74u rfmode=0
M$10 WBL[0] WWL[1] \$14 GND sg13_hv_nmos L=0.45u W=0.15u AS=0.0555p AD=0.1005p
+ PS=0.74u PD=1.34u rfmode=0
M$11 \$6 WWL[0] WBL[1] GND sg13_hv_nmos L=0.45u W=0.15u AS=0.1005p AD=0.0555p
+ PS=1.34u PD=0.74u rfmode=0
M$12 WBL[1] WWL[1] \$15 GND sg13_hv_nmos L=0.45u W=0.15u AS=0.0555p AD=0.1005p
+ PS=0.74u PD=1.34u rfmode=0
.ENDS GC_ARRAY_2x2
